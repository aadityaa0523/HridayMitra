* ===== HridayMitra: jewellery: toe ring bridging the left-foot plates =====

.param f=5000 path=1 fx=1 calv=3.3
.param fl={fx} ft={fx}
V1 vcc 0 3.3
R1 vcc vrefin 10k
R2 vrefin 0 10k
C1 vrefin 0 10u
Bu1a vref 0 V=limit(V(vrefin),0.05,3.25)
Vdac dac 0 SIN(1.65 {amp} {f})
C2 dac excin {c2}
R3 excin vref {r3}
Bu1b excout 0 V=limit(V(excin),0.05,3.25)
C3 excout n1 {c3}
R4 n1 injP {r4}
C4 injN ret {c4}
R5 ret ncal {r5}
Rcal ncal vref {rcal}
* --- body: arms to shoulder node SH, trunk SH-PV, legs to pelvis node PV (Cole: Re || Ri+Cm) ---
ReLH LH SH {330*sz}
RiLH LH mLH {750*sz}
CmLH mLH SH {2.9e-09/sz}
ReRH RH SH {330*sz}
RiRH RH mRH {750*sz}
CmRH mRH SH {2.9e-09/sz}
ReLF LF PV {290/fl*sz}
RiLF LF mLF {650*sz}
CmLF mLF PV {3.39e-09/sz}
ReRF RF PV {290/fl*sz}
RiRF RF mRF {650*sz}
CmRF mRF PV {3.39e-09/sz}
ReT SH PV {28/ft*sz}
RiT SH mT {60*sz}
CmT mT PV {3e-08/sz}
* --- electrodes: every hand/foot has an inject (i) and a sense (s) plate, each with contact Rc ---
RciLH iLH LH {rciLH}
RcsLH sLH LH {rcsLH}
RciRH iRH RH {rciRH}
RcsRH sRH RH {rcsRH}
RciLF iLF LF {rciLF}
RcsLF sLF LF {rcsLF}
RciRF iRF RF {rciRF}
RcsRF sRF RF {rcsRF}
* --- path mux (74HC4052, Ron 100 ohm): picks inject pair and sense pair ---
.model SW SW(Ron=100 Roff=1G Vt=1.65 Vh=0.1)
Bm1 c1 0 V=if(abs(path-2)<0.5,3.3,0) + if(abs(path-3)<0.5,3.3,0)
Sm1 injP iLH c1 0 SW
Bm2 c2 0 V=if(abs(path-4)<0.5,3.3,0)
Sm2 injP iRH c2 0 SW
Bm3 c3 0 V=if(abs(path-1)<0.5,3.3,0)
Sm3 injP iLF c3 0 SW
Bm4 c4 0 V=if(abs(path-2)<0.5,3.3,0)
Sm4 injN iRH c4 0 SW
Bm5 c5 0 V=if(abs(path-3)<0.5,3.3,0)
Sm5 injN iLF c5 0 SW
Bm6 c6 0 V=if(abs(path-1)<0.5,3.3,0) + if(abs(path-4)<0.5,3.3,0)
Sm6 injN iRF c6 0 SW
Bm7 c7 0 V=if(abs(path-2)<0.5,3.3,0) + if(abs(path-3)<0.5,3.3,0)
Sm7 sraw_p sLH c7 0 SW
Bm8 c8 0 V=if(abs(path-4)<0.5,3.3,0)
Sm8 sraw_p sRH c8 0 SW
Bm9 c9 0 V=if(abs(path-1)<0.5,3.3,0)
Sm9 sraw_p sLF c9 0 SW
Bm10 c10 0 V=if(abs(path-2)<0.5,3.3,0)
Sm10 sraw_n sRH c10 0 SW
Bm11 c11 0 V=if(abs(path-3)<0.5,3.3,0)
Sm11 sraw_n sLF c11 0 SW
Bm12 c12 0 V=if(abs(path-1)<0.5,3.3,0) + if(abs(path-4)<0.5,3.3,0)
Sm12 sraw_n sRF c12 0 SW
* --- sense lines: 1k protection, 1M bias to VREF ---
R6 sraw_p sa {r6}
R7 sraw_n sb {r7}
R8 sa vref {r8}
R9 sb vref {r9}
* --- 74HC4053 selector: selv=0 body, selv=3.3 reference; switch C (calv): 3.3 = across Rcal, 0 = across R5+Rcal ---
Vsel sel 0 PULSE(0 3.3 0.02 1u 1u 0.02 0.1)
Bch chi 0 V=V(sel)
Bcl clo 0 V=3.3-V(sel)
Vcal calsel 0 {calv}
Bcc ccal 0 V=V(calsel)
Bcn cnot 0 V=3.3-V(calsel)
S5 rtap ncal ccal 0 SW
S6 rtap ret cnot 0 SW
S1 inp sa clo 0 SW
S2 inp rtap chi 0 SW
S3 inn sb clo 0 SW
S4 inn vref chi 0 SW
Bina ina 0 V=limit(V(vref)+{gain}*(V(inp)-V(inn))+{gain}*{cmrr}*((V(inp)+V(inn))/2-V(vref)),0.05,3.25)
R11 ina adc {r11}
C5 adc 0 {c5}
Radc adc 0 10Meg
* --- DC definition of floating nodes ---
Rd0 n1 vref 1G
Rd1 injP vref 1G
Rd2 injN vref 1G
Rd3 SH vref 1G
Rd4 PV vref 1G
Rd5 mT vref 1G
Rd6 sraw_p vref 1G
Rd7 sraw_n vref 1G
Rd8 ncal vref 1G
Rd9 rtap vref 1G
Rd10 LH vref 1G
Rd11 RH vref 1G
Rd12 LF vref 1G
Rd13 RF vref 1G
Rd14 mLH vref 1G
Rd15 mRH vref 1G
Rd16 mLF vref 1G
Rd17 mRF vref 1G
Rd18 iLH vref 1G
Rd19 iRH vref 1G
Rd20 iLF vref 1G
Rd21 iRF vref 1G
Rd22 sLH vref 1G
Rd23 sRH vref 1G
Rd24 sLF vref 1G
Rd25 sRF vref 1G
.tran 0 0.04 0 5u
.step param rj list 1 10 100 1k 1G
.param run=1
.meas TRAN vbody PP V(adc) FROM=0.008 TO=0.019
.meas TRAN vsens PP V(adc) FROM=0.028 TO=0.039
.meas TRAN zmeas PARAM 100*vbody/vsens
.save V(adc) I(R4)
.param r3=table(run,1,100000)
.param r4=table(run,1,4700)
.param r5=table(run,1,120)
.param rcal=table(run,1,100)
.param r6=table(run,1,1000)
.param r7=table(run,1,1000)
.param r8=table(run,1,1e+07)
.param r9=table(run,1,1e+07)
.param r11=table(run,1,1500)
.param c2=table(run,1,1e-06)
.param c3=table(run,1,1e-06)
.param c4=table(run,1,1e-06)
.param c5=table(run,1,1e-08)
.param gain=table(run,1,10)
.param amp=table(run,1,0.83)
.param cmrr=table(run,1,0)
.param sz=table(run,1,1)
.param ibp=table(run,1,1e-08)
.param ibn=table(run,1,1e-08)
.param rciLH=table(run,1,1000)
.param rcsLH=table(run,1,1000)
.param rciRH=table(run,1,1000)
.param rcsRH=table(run,1,1000)
.param rciLF=table(run,1,1000)
.param rcsLF=table(run,1,1000)
.param rciRF=table(run,1,1000)
.param rcsRF=table(run,1,1000)
Ibp sa 0 {ibp}
Ibn sb 0 {ibn}
Rj iLF sLF {rj}
.end

* ===== HridayMitra: MC bias 10M =====

.param f=5000 path=1 fx=1
.param fl={fx} ft={fx}
V1 vcc 0 3.3
R1 vcc vrefin 10k
R2 vrefin 0 10k
C1 vrefin 0 10u
Bu1a vref 0 V=limit(V(vrefin),0.05,3.25)
Vdac dac 0 SIN(1.65 {amp} {f})
C2 dac excin {c2}
R3 excin vref {r3}
Bu1b excout 0 V=limit(V(excin),0.05,3.25)
C3 excout n1 {c3}
R4 n1 injP {r4}
C4 injN ret {c4}
R5 ret vref {r5}
* --- body: arms to shoulder node SH, trunk SH-PV, legs to pelvis node PV (Cole: Re || Ri+Cm) ---
ReLH LH SH {330*sz}
RiLH LH mLH {750*sz}
CmLH mLH SH {2.9e-09/sz}
ReRH RH SH {330*sz}
RiRH RH mRH {750*sz}
CmRH mRH SH {2.9e-09/sz}
ReLF LF PV {290/fl*sz}
RiLF LF mLF {650*sz}
CmLF mLF PV {3.39e-09/sz}
ReRF RF PV {290/fl*sz}
RiRF RF mRF {650*sz}
CmRF mRF PV {3.39e-09/sz}
ReT SH PV {28/ft*sz}
RiT SH mT {60*sz}
CmT mT PV {3e-08/sz}
* --- electrodes: every hand/foot has an inject (i) and a sense (s) plate, each with contact Rc ---
RciLH iLH LH {rciLH}
RcsLH sLH LH {rcsLH}
RciRH iRH RH {rciRH}
RcsRH sRH RH {rcsRH}
RciLF iLF LF {rciLF}
RcsLF sLF LF {rcsLF}
RciRF iRF RF {rciRF}
RcsRF sRF RF {rcsRF}
* --- path mux (74HC4052, Ron 100 ohm): picks inject pair and sense pair ---
.model SW SW(Ron=100 Roff=1G Vt=1.65 Vh=0.1)
Bm1 c1 0 V=if(abs(path-2)<0.5,3.3,0) + if(abs(path-3)<0.5,3.3,0)
Sm1 injP iLH c1 0 SW
Bm2 c2 0 V=if(abs(path-4)<0.5,3.3,0)
Sm2 injP iRH c2 0 SW
Bm3 c3 0 V=if(abs(path-1)<0.5,3.3,0)
Sm3 injP iLF c3 0 SW
Bm4 c4 0 V=if(abs(path-2)<0.5,3.3,0)
Sm4 injN iRH c4 0 SW
Bm5 c5 0 V=if(abs(path-3)<0.5,3.3,0)
Sm5 injN iLF c5 0 SW
Bm6 c6 0 V=if(abs(path-1)<0.5,3.3,0) + if(abs(path-4)<0.5,3.3,0)
Sm6 injN iRF c6 0 SW
Bm7 c7 0 V=if(abs(path-2)<0.5,3.3,0) + if(abs(path-3)<0.5,3.3,0)
Sm7 sraw_p sLH c7 0 SW
Bm8 c8 0 V=if(abs(path-4)<0.5,3.3,0)
Sm8 sraw_p sRH c8 0 SW
Bm9 c9 0 V=if(abs(path-1)<0.5,3.3,0)
Sm9 sraw_p sLF c9 0 SW
Bm10 c10 0 V=if(abs(path-2)<0.5,3.3,0)
Sm10 sraw_n sRH c10 0 SW
Bm11 c11 0 V=if(abs(path-3)<0.5,3.3,0)
Sm11 sraw_n sLF c11 0 SW
Bm12 c12 0 V=if(abs(path-1)<0.5,3.3,0) + if(abs(path-4)<0.5,3.3,0)
Sm12 sraw_n sRF c12 0 SW
* --- sense lines: 1k protection, 1M bias to VREF ---
R6 sraw_p sa {r6}
R7 sraw_n sb {r7}
R8 sa vref {r8}
R9 sb vref {r9}
* --- 74HC4053 selector: selv=0 body, selv=3.3 across R5 ---
Vsel sel 0 PULSE(0 3.3 0.02 1u 1u 0.02 0.1)
Bch chi 0 V=V(sel)
Bcl clo 0 V=3.3-V(sel)
S1 inp sa clo 0 SW
S2 inp ret chi 0 SW
S3 inn sb clo 0 SW
S4 inn vref chi 0 SW
Bina ina 0 V=limit(V(vref)+{gain}*(V(inp)-V(inn))+{gain}*{cmrr}*((V(inp)+V(inn))/2-V(vref)),0.05,3.25)
R11 ina adc {r11}
C5 adc 0 {c5}
Radc adc 0 10Meg
* --- DC definition of floating nodes ---
Rd0 n1 vref 1G
Rd1 injP vref 1G
Rd2 injN vref 1G
Rd3 SH vref 1G
Rd4 PV vref 1G
Rd5 mT vref 1G
Rd6 sraw_p vref 1G
Rd7 sraw_n vref 1G
Rd8 LH vref 1G
Rd9 RH vref 1G
Rd10 LF vref 1G
Rd11 RF vref 1G
Rd12 mLH vref 1G
Rd13 mRH vref 1G
Rd14 mLF vref 1G
Rd15 mRF vref 1G
Rd16 iLH vref 1G
Rd17 iRH vref 1G
Rd18 iLF vref 1G
Rd19 iRF vref 1G
Rd20 sLH vref 1G
Rd21 sRH vref 1G
Rd22 sLF vref 1G
Rd23 sRF vref 1G
.tran 0 0.04 0 5u
.step param fx list 1 1.1
.step param path list 1 2 3 4
.step param run 1 100 1
.meas TRAN vbody PP V(adc) FROM=0.008 TO=0.019
.meas TRAN vsens PP V(adc) FROM=0.028 TO=0.039
.meas TRAN zmeas PARAM 220*vbody/vsens
.save V(adc) I(R4)
.param r3=table(run,1,101251,2,100149,3,103713,4,96316.2,5,95303.5,6,100130,7,99300,8,101352,9,95210.8,10,96972.8,11,98805.8,12,101199,13,102210,14,102604,15,99550.2,16,103734,17,101815,18,98350.8,19,97222,20,103447,21,98771.4,22,99451.9,23,99880.8,24,97696.4,25,101119,26,99032.5,27,101289,28,96729.7,29,103126,30,96350.9,31,99870.3,32,98565.1,33,101958,34,104428,35,101363,36,104501,37,95932,38,103907,39,97803.8,40,99710.9,41,98340.1,42,100195,43,98940.8,44,103639,45,99093.5,46,102782,47,95573,48,100871,49,96278.7,50,102119,51,100217,52,103975,53,102150,54,103703,55,100425,56,95737.7,57,96340,58,102450,59,99215.2,60,96385.8,61,95116.8,62,102712,63,96907,64,99148.6,65,99611.6,66,97300.1,67,100132,68,96721.7,69,97013.6,70,97685.9,71,99872.6,72,101620,73,95760.5,74,104894,75,97807.8,76,97922,77,100315,78,98603.5,79,98882.3,80,103795,81,98674,82,95185.5,83,95927.3,84,98129.7,85,97101.6,86,104336,87,104759,88,99652.7,89,103959,90,104376,91,102741,92,98525.5,93,97886.2,94,101118,95,97914,96,102612,97,95432.8,98,97956.9,99,97370.4,100,97674.5)
.param r4=table(run,1,4886.69,2,4684.12,3,4634.79,4,4862.18,5,4522.76,6,4806.15,7,4709.17,8,4551.43,9,4610.97,10,4734.61,11,4527.85,12,4552.96,13,4933.48,14,4931.69,15,4491.68,16,4549.3,17,4810.77,18,4779.74,19,4556.91,20,4834.06,21,4590.44,22,4494.35,23,4898.9,24,4837.45,25,4778.01,26,4466.54,27,4678.71,28,4494.64,29,4685.69,30,4721.12,31,4711.3,32,4740.81,33,4525.56,34,4909.5,35,4552.69,36,4484.9,37,4614.48,38,4496.42,39,4906.39,40,4923.31,41,4748.22,42,4601.59,43,4702.43,44,4648.32,45,4904.65,46,4600.96,47,4801.3,48,4912.13,49,4881.27,50,4602.78,51,4910.5,52,4522.91,53,4684.36,54,4618.33,55,4757.7,56,4773.74,57,4602.43,58,4553.92,59,4865.28,60,4918.93,61,4801.14,62,4500.58,63,4466.31,64,4616.2,65,4588.99,66,4886.34,67,4680.43,68,4718.27,69,4470.83,70,4601.27,71,4678.66,72,4742.09,73,4887.97,74,4567.62,75,4629.31,76,4856.23,77,4524.08,78,4819.09,79,4733.66,80,4582.58,81,4674.27,82,4576.98,83,4559.43,84,4704.6,85,4665.65,86,4484.07,87,4763.77,88,4870.6,89,4774.79,90,4604.53,91,4475.15,92,4581.46,93,4926.72,94,4588.46,95,4664.23,96,4715.51,97,4590.79,98,4869.36,99,4745.18,100,4590.33)
.param r5=table(run,1,221.577,2,222.386,3,220.562,4,222.545,5,222.672,6,218.435,7,222.579,8,217.494,9,222.507,10,220.794,11,220.929,12,219.627,13,222.512,14,217.986,15,222.833,16,217.92,17,218.865,18,218.336,19,222.166,20,219.698,21,222.199,22,221.046,23,220.895,24,218.193,25,221.02,26,221.641,27,222.073,28,219.804,29,219.732,30,221.337,31,221.404,32,218.747,33,222.321,34,219.273,35,217.749,36,220.121,37,217.3,38,217.878,39,220.023,40,220.223,41,222.436,42,217.86,43,222.158,44,220.062,45,222.562,46,222.258,47,218.267,48,219.074,49,219.885,50,222.289,51,218.765,52,220.19,53,219.503,54,221.19,55,222.413,56,222.251,57,221.828,58,217.655,59,221.038,60,222.021,61,218.608,62,218.722,63,217.926,64,219.214,65,219.891,66,222.03,67,221.22,68,219.107,69,222.729,70,222.819,71,219.461,72,218.734,73,221.073,74,219.76,75,222.661,76,222.255,77,221.834,78,219.827,79,220.313,80,221.405,81,218.149,82,218.154,83,221.617,84,218.341,85,217.798,86,222.338,87,220.011,88,220.052,89,221.896,90,222.516,91,219.901,92,218.838,93,217.743,94,217.193,95,220.779,96,218.137,97,219.364,98,222.238,99,222.498,100,218.628)
.param r6=table(run,1,972.521,2,1012.92,3,955.925,4,1040.39,5,1015.78,6,969.852,7,975.1,8,991.152,9,1003.84,10,1010.93,11,1033.06,12,1038.39,13,1034.3,14,1021.27,15,1038.87,16,961.319,17,966.764,18,1005.17,19,969.784,20,1021.29,21,999.383,22,974.616,23,1012.09,24,1011.71,25,1007.01,26,974.548,27,979.294,28,971.44,29,1046.86,30,990.302,31,993.769,32,953.391,33,960.309,34,1044.02,35,1019.71,36,1010.13,37,971.919,38,1019.31,39,959.652,40,955.695,41,955.432,42,962.819,43,1017.28,44,961.414,45,953.004,46,958.276,47,976.581,48,990.81,49,962.487,50,1039.36,51,1049.94,52,955.005,53,986.565,54,976.411,55,1038.78,56,985.46,57,1049.24,58,996.278,59,1018.02,60,1014.71,61,1028.06,62,997.903,63,1035.12,64,1031.69,65,983.539,66,1012.9,67,1025.21,68,1015.51,69,979.372,70,972.754,71,966.09,72,1043.7,73,987,74,1047.21,75,984.146,76,1023.64,77,993.297,78,1009.65,79,1040.5,80,1013.5,81,999.599,82,975.735,83,1013.45,84,970.88,85,1014.57,86,1049.06,87,956.6,88,1013.18,89,1004.4,90,1041.88,91,1010.28,92,954.982,93,1003.03,94,1003.35,95,954.583,96,1048.23,97,975.22,98,1018.32,99,997.177,100,1001.55)
.param r7=table(run,1,980.017,2,1001.41,3,988.763,4,1006.97,5,992.822,6,986.313,7,1030.6,8,1026.4,9,1031.16,10,959.625,11,987.685,12,987.537,13,1027.71,14,1032.53,15,1041.63,16,1047.96,17,1025.65,18,1026.92,19,995.429,20,953.439,21,1018.55,22,1014.34,23,1026.77,24,990.631,25,1045.24,26,964.248,27,1025.77,28,1023.88,29,981.989,30,977.005,31,964.114,32,983.111,33,959.266,34,990.589,35,1025.64,36,1020.24,37,952.543,38,1031.21,39,954.589,40,992.878,41,1030.73,42,1030.12,43,959.436,44,1006.36,45,1049.45,46,961.899,47,982.478,48,1011.35,49,999.852,50,1043.64,51,1041.2,52,1043.92,53,999.341,54,1000.87,55,955.715,56,960.507,57,1011.16,58,973.452,59,1048.4,60,992.781,61,998.861,62,1017.62,63,1012.46,64,952.136,65,1026.71,66,1005.89,67,1034.91,68,1003.13,69,1003.75,70,954.711,71,979.531,72,990.945,73,1034.16,74,950.671,75,1007.87,76,983.282,77,1021.32,78,992.268,79,1032.71,80,988.614,81,973.089,82,1044.55,83,1029.72,84,990.23,85,958.702,86,984.628,87,962.117,88,987.419,89,1023.31,90,965.5,91,954.962,92,975.507,93,961.047,94,959.042,95,972.354,96,1045.08,97,967.689,98,1024.79,99,970.083,100,960.05)
.param r8=table(run,1,1.03736e+07,2,9.99687e+06,3,9.82304e+06,4,9.64546e+06,5,1.00237e+07,6,9.67941e+06,7,1.01765e+07,8,1.03152e+07,9,1.0158e+07,10,1.01612e+07,11,9.87172e+06,12,1.02109e+07,13,9.89502e+06,14,1.04206e+07,15,9.74658e+06,16,1.04416e+07,17,9.66584e+06,18,9.56531e+06,19,1.02503e+07,20,9.8898e+06,21,9.57329e+06,22,9.87662e+06,23,1.02503e+07,24,9.9176e+06,25,1.01079e+07,26,1.02995e+07,27,1.01357e+07,28,1.04225e+07,29,9.54172e+06,30,9.87228e+06,31,9.85361e+06,32,1.02552e+07,33,9.83155e+06,34,9.87477e+06,35,9.79636e+06,36,9.83591e+06,37,9.62616e+06,38,1.02866e+07,39,1.04904e+07,40,1.01603e+07,41,1.00418e+07,42,1.04224e+07,43,9.63684e+06,44,1.02664e+07,45,1.01049e+07,46,1.025e+07,47,1.00913e+07,48,1.03864e+07,49,9.74682e+06,50,9.75613e+06,51,9.8639e+06,52,9.67156e+06,53,9.78118e+06,54,1.01815e+07,55,1.02718e+07,56,1.01203e+07,57,1.03717e+07,58,1.03006e+07,59,9.71783e+06,60,9.69724e+06,61,1.00356e+07,62,1.01459e+07,63,1.04906e+07,64,9.6034e+06,65,1.03317e+07,66,9.72262e+06,67,1.03112e+07,68,1.01863e+07,69,9.8582e+06,70,9.91646e+06,71,9.76489e+06,72,1.00963e+07,73,1.02969e+07,74,9.79506e+06,75,1.04451e+07,76,9.96284e+06,77,1.03272e+07,78,1.0057e+07,79,1.02372e+07,80,1.0276e+07,81,9.66195e+06,82,9.5239e+06,83,9.54449e+06,84,1.02898e+07,85,9.67948e+06,86,1.02258e+07,87,1.03508e+07,88,9.65009e+06,89,9.62477e+06,90,1.03608e+07,91,9.79397e+06,92,1.04531e+07,93,9.68979e+06,94,1.02484e+07,95,9.60402e+06,96,1.04271e+07,97,1.03735e+07,98,9.69463e+06,99,1.00947e+07,100,1.02804e+07)
.param r9=table(run,1,9.50527e+06,2,9.74751e+06,3,9.6502e+06,4,9.69246e+06,5,1.03728e+07,6,9.84606e+06,7,1.02171e+07,8,1.023e+07,9,1.01108e+07,10,1.0132e+07,11,1.00395e+07,12,9.59681e+06,13,1.01412e+07,14,9.62338e+06,15,9.89411e+06,16,9.73067e+06,17,1.04195e+07,18,1.02278e+07,19,1.02073e+07,20,1.03603e+07,21,1.03666e+07,22,1.01372e+07,23,9.84384e+06,24,1.03168e+07,25,9.83573e+06,26,1.01863e+07,27,1.02404e+07,28,9.77298e+06,29,9.8922e+06,30,1.00417e+07,31,1.04821e+07,32,9.75584e+06,33,1.0438e+07,34,1.02566e+07,35,1.0136e+07,36,9.82791e+06,37,1.01332e+07,38,9.9524e+06,39,1.00792e+07,40,9.55671e+06,41,9.87907e+06,42,9.64187e+06,43,1.04907e+07,44,1.02313e+07,45,9.57385e+06,46,9.94918e+06,47,1.01279e+07,48,1.02061e+07,49,9.90784e+06,50,9.50066e+06,51,9.82724e+06,52,9.91002e+06,53,9.7421e+06,54,9.70112e+06,55,9.76136e+06,56,9.62704e+06,57,1.04842e+07,58,1.03172e+07,59,1.00079e+07,60,9.6062e+06,61,9.9572e+06,62,1.0225e+07,63,9.56946e+06,64,1.03078e+07,65,9.64117e+06,66,1.03751e+07,67,1.0169e+07,68,9.74634e+06,69,9.55341e+06,70,1.01495e+07,71,9.74818e+06,72,9.59103e+06,73,9.82644e+06,74,1.03212e+07,75,9.79759e+06,76,1.03346e+07,77,1.0038e+07,78,1.03974e+07,79,1.04238e+07,80,1.03975e+07,81,9.88062e+06,82,9.79875e+06,83,1.04008e+07,84,9.539e+06,85,1.02664e+07,86,1.03248e+07,87,1.02426e+07,88,1.01266e+07,89,1.04886e+07,90,1.02037e+07,91,1.04065e+07,92,9.5081e+06,93,1.02642e+07,94,9.84072e+06,95,1.02396e+07,96,1.03266e+07,97,9.525e+06,98,9.85426e+06,99,1.04575e+07,100,9.6748e+06)
.param r11=table(run,1,1548.18,2,1426.77,3,1547.45,4,1564.19,5,1476.63,6,1567.22,7,1519.44,8,1441.98,9,1453.69,10,1548.58,11,1457.26,12,1534.1,13,1452.67,14,1438.77,15,1459.08,16,1570.49,17,1514.5,18,1427.31,19,1508.02,20,1511.93,21,1471.94,22,1463.72,23,1463.55,24,1449.14,25,1501.93,26,1456.86,27,1481.74,28,1510.84,29,1448.01,30,1528,31,1537.61,32,1485.68,33,1429.95,34,1495.68,35,1430.11,36,1425.64,37,1440.07,38,1451.56,39,1433.17,40,1462.9,41,1477.54,42,1426.99,43,1429.37,44,1463.55,45,1499.55,46,1447.12,47,1564.72,48,1495.63,49,1521.04,50,1483.14,51,1443.98,52,1507.02,53,1447.27,54,1434.17,55,1529.58,56,1558.74,57,1536.08,58,1566.79,59,1438.88,60,1440.55,61,1526.4,62,1440.79,63,1479.9,64,1505.09,65,1449.66,66,1539.11,67,1533.17,68,1531.06,69,1560.13,70,1448.01,71,1542.42,72,1558.63,73,1552.08,74,1439.36,75,1546.34,76,1478.6,77,1432.45,78,1465.11,79,1434.92,80,1496.88,81,1434.59,82,1511.16,83,1482.34,84,1550.6,85,1500.04,86,1522.67,87,1550.26,88,1497.75,89,1545.03,90,1530.37,91,1574.15,92,1534.12,93,1434.91,94,1546.12,95,1458.19,96,1504.74,97,1452.28,98,1559.88,99,1555.21,100,1491.6)
.param c2=table(run,1,1.11883e-06,2,8.76961e-07,3,9.51778e-07,4,1.02093e-06,5,1.03612e-06,6,1.02933e-06,7,1.18862e-06,8,1.16534e-06,9,1.02976e-06,10,1.12141e-06,11,8.98964e-07,12,1.11059e-06,13,1.1038e-06,14,1.19515e-06,15,8.49963e-07,16,8.83127e-07,17,9.31774e-07,18,1.18334e-06,19,1.12282e-06,20,1.02313e-06,21,9.97811e-07,22,9.90615e-07,23,9.75049e-07,24,1.16952e-06,25,8.07465e-07,26,9.07033e-07,27,1.08997e-06,28,1.00269e-06,29,8.32757e-07,30,1.02367e-06,31,8.46538e-07,32,1.10199e-06,33,1.16728e-06,34,9.79279e-07,35,9.61728e-07,36,8.14095e-07,37,8.62305e-07,38,8.14121e-07,39,1.0045e-06,40,8.07334e-07,41,8.27765e-07,42,9.05453e-07,43,9.20349e-07,44,1.19675e-06,45,8.19789e-07,46,1.00537e-06,47,8.05087e-07,48,1.12583e-06,49,1.16615e-06,50,1.18503e-06,51,1.16626e-06,52,1.08746e-06,53,9.7609e-07,54,1.11638e-06,55,9.51793e-07,56,8.48983e-07,57,1.05789e-06,58,1.1359e-06,59,9.57116e-07,60,9.39657e-07,61,1.19602e-06,62,8.72301e-07,63,1.11828e-06,64,9.75556e-07,65,9.53465e-07,66,1.00517e-06,67,8.62851e-07,68,1.09385e-06,69,1.17426e-06,70,1.13588e-06,71,8.45615e-07,72,8.41201e-07,73,1.17176e-06,74,1.17132e-06,75,8.45632e-07,76,1.12212e-06,77,1.12899e-06,78,1.00762e-06,79,1.10785e-06,80,1.16644e-06,81,9.88142e-07,82,1.08124e-06,83,1.17047e-06,84,1.19611e-06,85,1.06475e-06,86,9.15562e-07,87,1.03123e-06,88,9.3825e-07,89,8.56977e-07,90,1.13616e-06,91,1.14012e-06,92,1.11557e-06,93,9.53084e-07,94,8.38222e-07,95,9.99333e-07,96,9.2018e-07,97,1.1041e-06,98,1.19451e-06,99,1.15958e-06,100,1.05673e-06)
.param c3=table(run,1,9.87174e-07,2,1.07681e-06,3,1.1915e-06,4,8.72221e-07,5,1.07347e-06,6,9.36027e-07,7,9.33073e-07,8,1.12081e-06,9,8.15875e-07,10,9.30867e-07,11,9.31941e-07,12,1.13031e-06,13,1.10308e-06,14,8.46703e-07,15,8.1321e-07,16,1.00259e-06,17,1.17466e-06,18,9.87468e-07,19,9.86326e-07,20,1.0659e-06,21,8.79208e-07,22,1.00987e-06,23,9.95699e-07,24,1.1574e-06,25,1.08965e-06,26,1.17569e-06,27,1.07937e-06,28,8.30043e-07,29,1.02714e-06,30,8.4281e-07,31,1.12328e-06,32,9.62673e-07,33,1.04464e-06,34,9.54448e-07,35,1.03118e-06,36,1.02002e-06,37,1.16112e-06,38,1.14055e-06,39,1.00164e-06,40,1.01603e-06,41,9.03351e-07,42,8.53776e-07,43,1.18356e-06,44,1.08797e-06,45,1.01956e-06,46,9.18788e-07,47,8.77375e-07,48,9.94122e-07,49,1.12037e-06,50,1.1055e-06,51,8.74324e-07,52,1.17498e-06,53,9.17305e-07,54,1.12358e-06,55,9.28831e-07,56,9.44748e-07,57,8.88496e-07,58,1.05898e-06,59,1.18014e-06,60,9.62859e-07,61,1.11915e-06,62,9.23592e-07,63,1.06448e-06,64,9.06927e-07,65,9.85315e-07,66,8.64407e-07,67,1.0797e-06,68,1.08879e-06,69,8.74573e-07,70,8.78583e-07,71,8.82168e-07,72,9.57619e-07,73,1.04796e-06,74,1.13382e-06,75,1.09333e-06,76,1.1128e-06,77,1.07762e-06,78,1.07489e-06,79,9.85447e-07,80,8.51048e-07,81,1.07845e-06,82,1.10951e-06,83,1.03781e-06,84,1.02366e-06,85,1.09358e-06,86,1.04916e-06,87,1.0304e-06,88,9.03408e-07,89,8.97046e-07,90,1.01467e-06,91,8.67879e-07,92,9.61884e-07,93,8.76662e-07,94,9.9759e-07,95,9.31405e-07,96,1.06068e-06,97,8.89324e-07,98,9.77222e-07,99,9.64209e-07,100,8.55209e-07)
.param c4=table(run,1,9.21213e-07,2,8.80243e-07,3,1.036e-06,4,1.15362e-06,5,9.42166e-07,6,9.0861e-07,7,9.5931e-07,8,1.15108e-06,9,1.12067e-06,10,1.08882e-06,11,9.8297e-07,12,1.06968e-06,13,1.08852e-06,14,8.70723e-07,15,1.00133e-06,16,9.98954e-07,17,8.62052e-07,18,9.63628e-07,19,1.04815e-06,20,1.07107e-06,21,9.68097e-07,22,1.05241e-06,23,8.56689e-07,24,1.06733e-06,25,1.07757e-06,26,9.07415e-07,27,9.54996e-07,28,8.4995e-07,29,1.18143e-06,30,1.12715e-06,31,9.24371e-07,32,1.15485e-06,33,8.26821e-07,34,9.73122e-07,35,9.01367e-07,36,8.30355e-07,37,9.34181e-07,38,1.19108e-06,39,9.74155e-07,40,9.52591e-07,41,1.04925e-06,42,8.75451e-07,43,8.06042e-07,44,9.69501e-07,45,8.74182e-07,46,1.01973e-06,47,9.44801e-07,48,1.18541e-06,49,8.64404e-07,50,8.23864e-07,51,8.03591e-07,52,1.09455e-06,53,1.13478e-06,54,1.06627e-06,55,9.95313e-07,56,9.97864e-07,57,9.4817e-07,58,8.74821e-07,59,8.34368e-07,60,1.16948e-06,61,8.27641e-07,62,9.12675e-07,63,8.26668e-07,64,1.01693e-06,65,1.18253e-06,66,8.86336e-07,67,9.01783e-07,68,8.2738e-07,69,9.67199e-07,70,1.08171e-06,71,1.01057e-06,72,1.15423e-06,73,9.40713e-07,74,8.57221e-07,75,1.12268e-06,76,9.87469e-07,77,1.16406e-06,78,8.34716e-07,79,1.10072e-06,80,8.66476e-07,81,1.06056e-06,82,9.53315e-07,83,1.01893e-06,84,9.44005e-07,85,1.04262e-06,86,1.15076e-06,87,1.01223e-06,88,1.0784e-06,89,1.02999e-06,90,1.00271e-06,91,1.10566e-06,92,1.0381e-06,93,1.14011e-06,94,8.39906e-07,95,8.94447e-07,96,8.60539e-07,97,9.03341e-07,98,1.11039e-06,99,9.04918e-07,100,9.63677e-07)
.param c5=table(run,1,9.55685e-09,2,9.73907e-09,3,1.02101e-08,4,1.02831e-08,5,1.00382e-08,6,1.09041e-08,7,9.40582e-09,8,1.00466e-08,9,1.09201e-08,10,1.07345e-08,11,9.16306e-09,12,9.74147e-09,13,9.8896e-09,14,1.01499e-08,15,9.24627e-09,16,1.08299e-08,17,1.00289e-08,18,1.04409e-08,19,1.06378e-08,20,1.01672e-08,21,1.06561e-08,22,9.40634e-09,23,9.88266e-09,24,9.09889e-09,25,9.8421e-09,26,1.04048e-08,27,9.0529e-09,28,1.07696e-08,29,1.01588e-08,30,1.08477e-08,31,1.05628e-08,32,1.08361e-08,33,1.01372e-08,34,9.27964e-09,35,9.69643e-09,36,9.40496e-09,37,9.66599e-09,38,9.48827e-09,39,1.09026e-08,40,1.00074e-08,41,9.19518e-09,42,1.01667e-08,43,9.3228e-09,44,9.82982e-09,45,9.73588e-09,46,1.04874e-08,47,1.0636e-08,48,9.565e-09,49,9.95467e-09,50,1.04051e-08,51,1.07802e-08,52,9.69474e-09,53,1.06958e-08,54,9.64286e-09,55,1.00611e-08,56,9.23575e-09,57,1.02471e-08,58,1.0646e-08,59,1.05154e-08,60,1.00725e-08,61,9.9896e-09,62,1.05112e-08,63,9.80288e-09,64,9.44313e-09,65,1.08834e-08,66,9.75859e-09,67,9.51567e-09,68,1.08923e-08,69,9.74728e-09,70,9.32362e-09,71,9.62508e-09,72,1.089e-08,73,1.08012e-08,74,1.01847e-08,75,1.06749e-08,76,1.07931e-08,77,9.54027e-09,78,1.0924e-08,79,9.59236e-09,80,1.05284e-08,81,1.09505e-08,82,9.44035e-09,83,1.06362e-08,84,9.46787e-09,85,9.39552e-09,86,9.21409e-09,87,1.04702e-08,88,9.63582e-09,89,1.05255e-08,90,9.73406e-09,91,9.90173e-09,92,9.44177e-09,93,9.16475e-09,94,1.05607e-08,95,1.08704e-08,96,1.02336e-08,97,1.09349e-08,98,1.08669e-08,99,1.07412e-08,100,1.01263e-08)
.param gain=table(run,1,9.97549,2,9.95037,3,10.0138,4,10.007,5,10.0265,6,9.99445,7,9.95507,8,10.0416,9,10.0354,10,10.0393,11,10.0253,12,9.95642,13,9.98782,14,9.99463,15,9.96763,16,9.95405,17,9.95916,18,10.0023,19,10.0178,20,9.99206,21,10.0328,22,10.0462,23,10.014,24,10.0163,25,10.0351,26,9.96296,27,10.0463,28,9.99742,29,10.0147,30,9.96013,31,9.95127,32,9.98105,33,9.99588,34,9.9561,35,10.011,36,9.98333,37,9.95865,38,10.0366,39,10.0449,40,9.97958,41,10.0169,42,9.99223,43,9.97134,44,10.0279,45,9.98047,46,10.0357,47,10.005,48,9.96274,49,9.99919,50,10.0417,51,10.0098,52,9.95753,53,9.98439,54,10.0158,55,10.0194,56,9.98187,57,10.0426,58,10.0228,59,10.0365,60,10.0491,61,9.97343,62,10.0493,63,10.0138,64,10.0358,65,10.0467,66,9.98311,67,9.96201,68,10.0077,69,9.96672,70,10.0382,71,9.97402,72,10.0404,73,10.0443,74,10.0055,75,10.0475,76,9.98845,77,10.0285,78,9.99988,79,9.99673,80,9.98056,81,10.0386,82,10.0352,83,10.0125,84,9.9683,85,10.0198,86,9.998,87,9.98302,88,10.0076,89,9.96489,90,10.0365,91,9.96706,92,10.0168,93,9.98366,94,10.006,95,10.0007,96,9.95661,97,10.0263,98,10.0497,99,10.0288,100,10.005)
.param amp=table(run,1,0.822706,2,0.87383,3,0.853433,4,0.813571,5,0.884339,6,0.893796,7,0.791874,8,0.769795,9,0.770334,10,0.785049,11,0.840498,12,0.832493,13,0.819346,14,0.863252,15,0.877871,16,0.805479,17,0.891809,18,0.860657,19,0.848835,20,0.787967,21,0.826504,22,0.801998,23,0.781623,24,0.843326,25,0.863934,26,0.871837,27,0.858366,28,0.870452,29,0.806578,30,0.796736,31,0.879305,32,0.861336,33,0.838497,34,0.86373,35,0.841938,36,0.772959,37,0.8693,38,0.817056,39,0.780196,40,0.850824,41,0.891387,42,0.820602,43,0.775073,44,0.786931,45,0.843574,46,0.771435,47,0.831592,48,0.873877,49,0.895003,50,0.892113,51,0.852822,52,0.857543,53,0.845822,54,0.774739,55,0.848311,56,0.800157,57,0.803685,58,0.862784,59,0.831188,60,0.859334,61,0.777199,62,0.854318,63,0.854934,64,0.873032,65,0.860512,66,0.771708,67,0.81631,68,0.799764,69,0.851469,70,0.790335,71,0.813185,72,0.873504,73,0.809719,74,0.855722,75,0.858013,76,0.863189,77,0.87955,78,0.796181,79,0.873106,80,0.841337,81,0.847762,82,0.779814,83,0.853183,84,0.806539,85,0.778997,86,0.766607,87,0.829563,88,0.798094,89,0.891173,90,0.883266,91,0.827462,92,0.857599,93,0.877309,94,0.794767,95,0.849982,96,0.765404,97,0.823183,98,0.802876,99,0.876663,100,0.882127)
.param cmrr=table(run,1,-0.000279578,2,0.000700711,3,0.000362816,4,-0.00038819,5,0.000116568,6,-0.000305125,7,-0.000144488,8,0.000932634,9,0.000480836,10,-0.000940368,11,0.000836476,12,-0.000174799,13,-0.000143113,14,-0.000644826,15,0.000655083,16,-0.000251203,17,-0.000157157,18,0.000822701,19,-0.000276488,20,-0.000509751,21,0.000348284,22,0.000494288,23,0.000670314,24,-0.000168964,25,-0.00083657,26,-0.000762799,27,-0.000185863,28,-0.000857866,29,0.000176911,30,0.000670377,31,0.000350146,32,-0.00055832,33,-0.000209595,34,0.000272584,35,0.000196525,36,-0.000931408,37,0.000283705,38,0.000488266,39,0.000391301,40,-0.000671296,41,-0.00012905,42,0.000622856,43,0.000255601,44,-0.000229283,45,-0.000115735,46,0.00025565,47,0.000221279,48,0.000504314,49,0.000308484,50,-0.000192314,51,0.000906439,52,0.000106534,53,-0.000437359,54,0.000217516,55,-0.000412974,56,0.000193508,57,-0.000950086,58,-0.000200709,59,0.000362205,60,0.000714012,61,-0.000564788,62,-0.000926731,63,0.000648384,64,-0.000476595,65,-0.000536548,66,0.000392305,67,0.000220303,68,-0.000368013,69,-0.000173901,70,0.000185627,71,0.000211673,72,0.000584385,73,0.000135578,74,-0.000493355,75,-0.000526801,76,0.000229219,77,-0.000388877,78,-0.000173608,79,-0.000511533,80,-0.000318368,81,-0.00035938,82,0.00086095,83,-0.000248624,84,-0.000140716,85,-0.000356339,86,-0.000142902,87,-0.000217953,88,-0.000176436,89,-0.000101164,90,-0.000690964,91,-0.000132662,92,0.00018426,93,0.000198003,94,0.00010893,95,0.000150955,96,0.000192524,97,0.000538212,98,-0.000221784,99,-0.000517419,100,-0.000164056)
.param sz=table(run,1,1.39685,2,0.88732,3,0.867695,4,0.867642,5,0.703625,6,1.06482,7,0.778684,8,0.714151,9,0.778902,10,1.15557,11,1.23423,12,0.833587,13,1.07966,14,1.3401,15,1.16891,16,0.746479,17,0.897346,18,1.09395,19,0.977258,20,0.905046,21,0.961349,22,0.879419,23,0.898332,24,0.849682,25,0.792556,26,1.06123,27,0.895078,28,1.11637,29,1.1125,30,1.29441,31,1.16323,32,0.797666,33,1.39806,34,1.17032,35,0.75602,36,1.34884,37,1.13254,38,1.05361,39,1.28382,40,1.33466,41,1.26463,42,1.16521,43,0.922825,44,1.20319,45,0.930201,46,1.38857,47,0.902899,48,1.29318,49,1.34005,50,1.3041,51,0.764298,52,0.711911,53,1.0883,54,1.10334,55,1.17414,56,1.39039,57,1.18771,58,1.28102,59,0.947348,60,1.0875,61,1.37181,62,0.908316,63,1.37615,64,0.71715,65,0.960858,66,1.0141,67,1.22367,68,1.06232,69,1.17268,70,1.28709,71,1.38056,72,0.722298,73,1.16536,74,0.968908,75,1.06509,76,0.931875,77,0.933791,78,1.27091,79,1.04192,80,0.80205,81,1.25921,82,0.862106,83,0.94955,84,0.702279,85,0.780109,86,1.24494,87,0.851348,88,0.962465,89,1.22681,90,1.24052,91,0.974074,92,1.04421,93,1.39383,94,1.1774,95,0.884253,96,0.939898,97,1.38681,98,0.972986,99,0.86821,100,0.784637)
.param rciLH=table(run,1,4443.64,2,6261.64,3,965.745,4,232.107,5,3804.66,6,6671.53,7,2122.43,8,537.621,9,2320.73,10,463.189,11,333.987,12,566.708,13,910.778,14,467.776,15,565.883,16,504.571,17,4605.31,18,1775.17,19,3677.56,20,1078.58,21,1692.31,22,260.417,23,8608.85,24,8332.08,25,411.247,26,229.543,27,1254.1,28,5904.31,29,4623.03,30,7039.9,31,1458.43,32,1109.12,33,369.153,34,4615.02,35,8883.07,36,1097.58,37,296.192,38,206.494,39,2294.92,40,8554.2,41,401.206,42,620.725,43,305.93,44,1507.57,45,1857.45,46,1208.4,47,281.215,48,2169.65,49,952.057,50,5383.4,51,1413.31,52,4141.78,53,1134.03,54,2236.87,55,772.383,56,826.951,57,1134.08,58,641.294,59,1446.28,60,373.075,61,3685.81,62,4627.53,63,1240.51,64,6443.93,65,202.11,66,614.851,67,4155.9,68,1516.02,69,214.164,70,542.221,71,5618.72,72,1171.23,73,495.664,74,513.031,75,462.1,76,1601.46,77,204.532,78,2357.4,79,5593.8,80,3823.41,81,608.628,82,1373.79,83,268.814,84,4328.96,85,302.764,86,239.464,87,220.613,88,1300.1,89,1336.34,90,587.646,91,256.25,92,8907.12,93,219.19,94,745.53,95,271.994,96,3059.42,97,4416.19,98,1233.65,99,6028.2,100,5207.77)
.param rcsLH=table(run,1,2280.83,2,1469.43,3,291.963,4,6161.68,5,4765.31,6,3655.69,7,1303.68,8,528.862,9,4527.8,10,1814.5,11,336.778,12,1628.85,13,1706.53,14,4052.53,15,1571.38,16,1233.56,17,3127.07,18,7667.67,19,885.869,20,9963.25,21,439.645,22,1046.08,23,221.232,24,6406.97,25,656.716,26,1720.27,27,5780.35,28,5944.96,29,1722.91,30,237.821,31,381.976,32,2111.6,33,4808.91,34,492.009,35,441.405,36,445.782,37,553.71,38,1130.29,39,3475.28,40,1375.98,41,8898.07,42,953.166,43,4773.31,44,6089.31,45,204.669,46,4059.76,47,1220.32,48,1464.66,49,556.776,50,812.522,51,243.457,52,398.373,53,2545.72,54,1149.33,55,2153.83,56,4410,57,4532.65,58,2776.54,59,428.443,60,233.149,61,5625.99,62,7438,63,3309.6,64,643.375,65,5202.31,66,899.392,67,331.103,68,527.599,69,491.031,70,287.567,71,1075.41,72,256.077,73,1837.48,74,626.554,75,277.295,76,2141.28,77,494.811,78,7203.82,79,575.186,80,3636.65,81,1569.94,82,7974.98,83,336.758,84,2722.55,85,2565.77,86,3699.48,87,282.808,88,7532.85,89,826.508,90,410.58,91,6777.09,92,5927.53,93,2694.86,94,5678.24,95,1244.13,96,4228.01,97,262.877,98,1218.47,99,7296.27,100,1718.35)
.param rciRH=table(run,1,9577.31,2,5499.37,3,8817.41,4,1246.49,5,341.498,6,1938.84,7,2048.24,8,416.478,9,682.391,10,8057.95,11,333.471,12,3736.14,13,3365.7,14,260.547,15,605.004,16,6274.51,17,2480.99,18,233.517,19,1241.1,20,794.338,21,690.015,22,4095.97,23,410.39,24,312.838,25,1151.72,26,5488.01,27,1154.23,28,204.528,29,434.181,30,734.177,31,344.658,32,7772.68,33,998.768,34,499.118,35,539.263,36,3196.45,37,1961.64,38,436.584,39,1904.3,40,1235.13,41,442.029,42,1225.62,43,4653.75,44,1250.92,45,857.679,46,292.599,47,6257.58,48,281.122,49,1760.13,50,294.647,51,1438.33,52,1209.14,53,8543.82,54,482.578,55,1207.15,56,346.31,57,498.888,58,1513.23,59,665.948,60,8025.94,61,3078.28,62,2050.07,63,1620.64,64,2612.41,65,588.966,66,734.057,67,2455.94,68,563.893,69,1497.35,70,1980.92,71,1170.44,72,8569.37,73,667.793,74,397.73,75,1113.7,76,1633.36,77,731.645,78,283.196,79,5005.05,80,352.961,81,9242.65,82,3462.01,83,1306.76,84,215.446,85,3644.13,86,2992.02,87,403.234,88,3323.07,89,291.717,90,432.595,91,9477.62,92,1877.67,93,3687.15,94,884.318,95,388.925,96,5250.32,97,3176.4,98,594.592,99,841.068,100,2839.29)
.param rcsRH=table(run,1,464.337,2,2442.81,3,463.784,4,1703.91,5,1029.76,6,1061.44,7,2637.05,8,1838.4,9,5846.78,10,882.029,11,274.848,12,6672.74,13,889.448,14,1274.46,15,1506.51,16,3925.34,17,8241.53,18,1175.86,19,3841.75,20,1151.1,21,3172.5,22,3210.43,23,381.453,24,686.355,25,7545.16,26,278.241,27,617.084,28,1539.63,29,1954.63,30,424.691,31,608.759,32,353.926,33,4283.97,34,593.183,35,437.859,36,207.528,37,8295.52,38,3246.93,39,454.894,40,5774.22,41,5991.28,42,6880.5,43,1803.1,44,1232.73,45,8575.06,46,6096.68,47,2076.13,48,4334.67,49,699.601,50,3443.26,51,3564.9,52,1545.16,53,343.991,54,3421.95,55,1808.04,56,1933.24,57,2640.88,58,749.923,59,660.473,60,749.953,61,687.57,62,782.833,63,274.236,64,5741.3,65,272.726,66,873.499,67,5312.09,68,829.383,69,3127.05,70,1408.81,71,1016.98,72,206.51,73,7289.6,74,6879.92,75,3339.99,76,308.417,77,305.636,78,1575.45,79,520.599,80,552.553,81,2081.48,82,1816.36,83,558.493,84,262.536,85,852.752,86,327.738,87,5720.88,88,3564.8,89,282.079,90,1883.91,91,1478.68,92,2886.31,93,3733.83,94,7984.54,95,216.642,96,2224.87,97,870.753,98,215.487,99,6121.38,100,373.96)
.param rciLF=table(run,1,374.305,2,3641.47,3,2769.1,4,705.303,5,4854.29,6,6209.33,7,663.797,8,232.952,9,4521.94,10,537.634,11,6933.67,12,327.085,13,5155.41,14,227.167,15,2338.24,16,5122.04,17,1090.23,18,2361.59,19,1434.58,20,855.882,21,4074.84,22,429.835,23,1279.18,24,227.066,25,594.366,26,584.768,27,660.77,28,847.145,29,1364.95,30,1255.31,31,245.495,32,3245.73,33,6548.41,34,656.734,35,9672.91,36,521.563,37,4890.04,38,1428.51,39,4902.18,40,621.521,41,6201.7,42,524.301,43,342.807,44,609.105,45,318.371,46,1949.49,47,246.358,48,258.841,49,7518.13,50,341.697,51,2617.87,52,2212.7,53,8733.55,54,1229.06,55,214.204,56,1086.92,57,2783.52,58,718.324,59,9556.67,60,419.886,61,923.648,62,802.353,63,504.852,64,4543.84,65,687.401,66,2252.92,67,230.219,68,4244.22,69,906.885,70,1304.31,71,509.297,72,714.516,73,762.558,74,6437.79,75,4203.28,76,9671.08,77,3996.57,78,3657.45,79,654.748,80,4583.52,81,1452.29,82,1536.62,83,3992.92,84,3547.14,85,919.139,86,1560.54,87,3303.05,88,754.33,89,2346.67,90,597.518,91,482.807,92,585.981,93,3266.86,94,639.471,95,7303.75,96,5490.49,97,3342.92,98,4011.84,99,889.211,100,1267.39)
.param rcsLF=table(run,1,2196.43,2,286.074,3,647.791,4,3780.15,5,211.483,6,1000.93,7,8596.79,8,2014.1,9,331.46,10,1192.96,11,573.414,12,411.244,13,7297.44,14,682.629,15,1629.41,16,3927.03,17,1014.5,18,1724.78,19,750.477,20,1944.73,21,249.675,22,341.722,23,212.148,24,5161.6,25,6725.12,26,3983.09,27,270.321,28,3911.28,29,382.78,30,7358.42,31,466.587,32,1284.78,33,9691.82,34,3921.22,35,613.686,36,8576.59,37,2452.48,38,5986.66,39,211.277,40,4628.95,41,2278.42,42,3326.76,43,1666.18,44,7294.82,45,6009.54,46,6458.96,47,1118.68,48,8725.55,49,278.677,50,899.026,51,2232.01,52,9598.94,53,2704.53,54,3693.25,55,1407.52,56,617.512,57,1229.99,58,367.422,59,742.099,60,297.832,61,1121.33,62,2383.55,63,255.922,64,5839.74,65,708.086,66,1399.52,67,426.145,68,1107.22,69,1159.63,70,4251.03,71,8280.39,72,443.014,73,430.989,74,817.876,75,213.743,76,8775.3,77,1062.7,78,7222.32,79,1745.62,80,7093.86,81,4351.53,82,3013.88,83,322.836,84,2784.37,85,450.545,86,2966.41,87,3760.18,88,5354.74,89,4123.05,90,516.006,91,1678.49,92,8020.95,93,265.288,94,9406.54,95,2320.49,96,2632.87,97,635.308,98,3044.09,99,1153.49,100,3091.48)
.param rciRF=table(run,1,237.512,2,1661.18,3,6110.27,4,220.718,5,2337.59,6,7392.15,7,1237.31,8,382.893,9,4016.99,10,2616.18,11,663.151,12,4564.77,13,910.47,14,678.423,15,940.047,16,3187.33,17,2998.63,18,267.318,19,5078.91,20,8156.08,21,3516.25,22,703.277,23,1200.75,24,7173.79,25,2864.94,26,2158.59,27,472.023,28,266.334,29,2254.11,30,263.18,31,332.717,32,334.811,33,566.275,34,864.477,35,2135.03,36,6701.6,37,1522.25,38,6674.34,39,3074.21,40,615.399,41,1537.14,42,670.87,43,2347.32,44,689.228,45,2568.13,46,4348.3,47,900.481,48,6179.93,49,448.973,50,9834.57,51,239.813,52,2943.78,53,4499.77,54,831.306,55,472.878,56,4978.42,57,418.278,58,1368.15,59,489.633,60,2564.47,61,630.261,62,5878.47,63,421.847,64,1355.36,65,3396.72,66,433.24,67,570.129,68,232.629,69,5362.74,70,1224.16,71,261.626,72,211.004,73,236.832,74,3011.53,75,7976.86,76,231.578,77,1846.75,78,2459.4,79,2582.23,80,6015.71,81,678.759,82,2319.41,83,211.11,84,681.781,85,1539.08,86,743.036,87,1137,88,904.528,89,6964.93,90,294.016,91,3047.74,92,2495.21,93,277.74,94,255.38,95,1011.63,96,7524.05,97,332.795,98,5360.18,99,1834.28,100,4527.71)
.param rcsRF=table(run,1,229.959,2,1457.87,3,2667.55,4,857.752,5,4449.93,6,261.683,7,2334.29,8,2836.07,9,6317.95,10,297.026,11,5199.03,12,2489.16,13,342.906,14,3340.88,15,4411.63,16,5554.35,17,5245.22,18,2036.61,19,887.716,20,6479.45,21,4895.75,22,4038.99,23,378.295,24,9609.18,25,5637.53,26,679.927,27,577.606,28,563.809,29,4886.76,30,390.866,31,1232.27,32,8985.6,33,1176.41,34,708.138,35,9640.24,36,2406.84,37,212.197,38,690.548,39,427.767,40,3343.71,41,438.073,42,6616.58,43,1068.28,44,3035.81,45,631.461,46,5995.73,47,1952.33,48,654.281,49,277.667,50,1786.85,51,504.777,52,928.292,53,2399.29,54,281.956,55,904.719,56,3708.33,57,967.261,58,846.194,59,7900.71,60,1214.81,61,1040.04,62,758.739,63,437.664,64,5395.86,65,204.515,66,4489.03,67,1218.79,68,1173.06,69,219.298,70,1397.89,71,445.892,72,1409.12,73,763.759,74,1361.42,75,526.105,76,8041.43,77,608.931,78,2110.28,79,6255.22,80,1424.55,81,5163.56,82,745.44,83,9882.54,84,5812.14,85,1936.68,86,1435.95,87,298.975,88,9552.83,89,833.942,90,712.371,91,1319.12,92,6629.47,93,4111.47,94,3540.33,95,341.072,96,6679.61,97,216.023,98,364.325,99,475.351,100,4678.21)

.end

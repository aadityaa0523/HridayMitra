* ===== HridayMitra: OPEN ME: chest (trunk) paths Z1-Z4, 5 kHz =====
* HOW TO USE: File > Open this file in LTspice, press Run (running man). It runs 4 times, once per path.
*   Answer: View > SPICE Output Log, find 'zmeas' (one value per path, ohm). Expected (exact model, 5 kHz):
*     path 1 legs Z1 = 578.5   path 2 arms Z2 = 658.4   path 3 left Z3 = 646.4   path 4 right Z4 = 646.4
*     chest (trunk) = (Z3 + Z4 - Z1 - Z2) / 2 = 27.95 ohm. Pass if every zmeas is within 1 % of these.
*   Plot: right-click > Add Trace > V(adc). First 20 ms = body signal, next 20 ms = across the 220 ohm reference.
*   Try: set ft=1.1 (+10 % chest fluid) on the .param line: the chest number should fall about 9 %.
*   Try: set Rc=10k (dry skin): the numbers should barely move (that is the point of 4-electrode sensing).
.param f=5000 Rc=1k ft=1 fl=1 path=1 selv=0
V1 vcc 0 3.3
R1 vcc vrefin 10k
R2 vrefin 0 10k
C1 vrefin 0 10u
Bu1a vref 0 V=limit(V(vrefin),0.05,3.25)
Vdac dac 0 SIN(1.65 0.83 {f})
C2 dac excin 1u
R3 excin vref 100k
Bu1b excout 0 V=limit(V(excin),0.05,3.25)
C3 excout n1 1u
R4 n1 injP 4.7k
C4 injN ret 1u
R5 ret vref 220
* --- body: arms to shoulder node SH, trunk SH-PV, legs to pelvis node PV (Cole: Re || Ri+Cm) ---
ReLH LH SH 330
RiLH LH mLH 750
CmLH mLH SH 2.9e-09
ReRH RH SH 330
RiRH RH mRH 750
CmRH mRH SH 2.9e-09
ReLF LF PV {290/fl}
RiLF LF mLF 650
CmLF mLF PV 3.39e-09
ReRF RF PV {290/fl}
RiRF RF mRF 650
CmRF mRF PV 3.39e-09
ReT SH PV {28/ft}
RiT SH mT 60
CmT mT PV 3e-08
* --- electrodes: every hand/foot has an inject (i) and a sense (s) plate, each with contact Rc ---
RciLH iLH LH {Rc}
RcsLH sLH LH {Rc}
RciRH iRH RH {Rc}
RcsRH sRH RH {Rc}
RciLF iLF LF {Rc}
RcsLF sLF LF {Rc}
RciRF iRF RF {Rc}
RcsRF sRF RF {Rc}
* --- path mux (74HC4052, Ron 100 ohm): picks inject pair and sense pair ---
.model SW SW(Ron=100 Roff=1G Vt=1.65 Vh=0.1)
Bm1 c1 0 V=if(abs(path-2)<0.5,3.3,0) + if(abs(path-3)<0.5,3.3,0)
Sm1 injP iLH c1 0 SW
Bm2 c2 0 V=if(abs(path-4)<0.5,3.3,0)
Sm2 injP iRH c2 0 SW
Bm3 c3 0 V=if(abs(path-1)<0.5,3.3,0)
Sm3 injP iLF c3 0 SW
Bm4 c4 0 V=if(abs(path-2)<0.5,3.3,0)
Sm4 injN iRH c4 0 SW
Bm5 c5 0 V=if(abs(path-3)<0.5,3.3,0)
Sm5 injN iLF c5 0 SW
Bm6 c6 0 V=if(abs(path-1)<0.5,3.3,0) + if(abs(path-4)<0.5,3.3,0)
Sm6 injN iRF c6 0 SW
Bm7 c7 0 V=if(abs(path-2)<0.5,3.3,0) + if(abs(path-3)<0.5,3.3,0)
Sm7 sraw_p sLH c7 0 SW
Bm8 c8 0 V=if(abs(path-4)<0.5,3.3,0)
Sm8 sraw_p sRH c8 0 SW
Bm9 c9 0 V=if(abs(path-1)<0.5,3.3,0)
Sm9 sraw_p sLF c9 0 SW
Bm10 c10 0 V=if(abs(path-2)<0.5,3.3,0)
Sm10 sraw_n sRH c10 0 SW
Bm11 c11 0 V=if(abs(path-3)<0.5,3.3,0)
Sm11 sraw_n sLF c11 0 SW
Bm12 c12 0 V=if(abs(path-1)<0.5,3.3,0) + if(abs(path-4)<0.5,3.3,0)
Sm12 sraw_n sRF c12 0 SW
* --- sense lines: 1k protection, 1M bias to VREF ---
R6 sraw_p sa 1k
R7 sraw_n sb 1k
R8 sa vref 10Meg
R9 sb vref 10Meg
* --- 74HC4053 selector: selv=0 body, selv=3.3 across R5 ---
Vsel sel 0 PULSE(0 3.3 0.02 1u 1u 0.02 0.1)   ; low = body, high = across R5
Bch chi 0 V=V(sel)
Bcl clo 0 V=3.3-V(sel)
S1 inp sa clo 0 SW
S2 inp ret chi 0 SW
S3 inn sb clo 0 SW
S4 inn vref chi 0 SW
Bina ina 0 V=limit(V(vref)+10*(V(inp)-V(inn)),0.05,3.25)
R11 ina adc 1.5k
C5 adc 0 10n
Radc adc 0 10Meg
* --- DC definition of floating nodes ---
Rd0 n1 vref 1G
Rd1 injP vref 1G
Rd2 injN vref 1G
Rd3 SH vref 1G
Rd4 PV vref 1G
Rd5 mT vref 1G
Rd6 sraw_p vref 1G
Rd7 sraw_n vref 1G
Rd8 LH vref 1G
Rd9 RH vref 1G
Rd10 LF vref 1G
Rd11 RF vref 1G
Rd12 mLH vref 1G
Rd13 mRH vref 1G
Rd14 mLF vref 1G
Rd15 mRF vref 1G
Rd16 iLH vref 1G
Rd17 iRH vref 1G
Rd18 iLF vref 1G
Rd19 iRF vref 1G
Rd20 sLH vref 1G
Rd21 sRH vref 1G
Rd22 sLF vref 1G
Rd23 sRF vref 1G
.tran 0 0.04 0 5u
.step param path list 1 2 3 4
.meas TRAN vbody PP V(adc) FROM=0.008 TO=0.019
.meas TRAN vsens PP V(adc) FROM=0.028 TO=0.039
.meas TRAN zmeas PARAM 220*vbody/vsens
.save V(adc) I(R4)
.end

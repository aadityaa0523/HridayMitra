* ===== HridayMitra: Monte Carlo, 100 devices x 4 paths x 2 fluid levels =====

.param f=5000 path=1 fx=1
.param fl={fx} ft={fx}
V1 vcc 0 3.3
R1 vcc vrefin 10k
R2 vrefin 0 10k
C1 vrefin 0 10u
Bu1a vref 0 V=limit(V(vrefin),0.05,3.25)
Vdac dac 0 SIN(1.65 {amp} {f})
C2 dac excin {c2}
R3 excin vref {r3}
Bu1b excout 0 V=limit(V(excin),0.05,3.25)
C3 excout n1 {c3}
R4 n1 injP {r4}
C4 injN ret {c4}
R5 ret vref {r5}
* --- body: arms to shoulder node SH, trunk SH-PV, legs to pelvis node PV (Cole: Re || Ri+Cm) ---
ReLH LH SH {330*sz}
RiLH LH mLH {750*sz}
CmLH mLH SH {2.9e-09/sz}
ReRH RH SH {330*sz}
RiRH RH mRH {750*sz}
CmRH mRH SH {2.9e-09/sz}
ReLF LF PV {290/fl*sz}
RiLF LF mLF {650*sz}
CmLF mLF PV {3.39e-09/sz}
ReRF RF PV {290/fl*sz}
RiRF RF mRF {650*sz}
CmRF mRF PV {3.39e-09/sz}
ReT SH PV {28/ft*sz}
RiT SH mT {60*sz}
CmT mT PV {3e-08/sz}
* --- electrodes: every hand/foot has an inject (i) and a sense (s) plate, each with contact Rc ---
RciLH iLH LH {rciLH}
RcsLH sLH LH {rcsLH}
RciRH iRH RH {rciRH}
RcsRH sRH RH {rcsRH}
RciLF iLF LF {rciLF}
RcsLF sLF LF {rcsLF}
RciRF iRF RF {rciRF}
RcsRF sRF RF {rcsRF}
* --- path mux (74HC4052, Ron 100 ohm): picks inject pair and sense pair ---
.model SW SW(Ron=100 Roff=1G Vt=1.65 Vh=0.1)
Bm1 c1 0 V=if(abs(path-2)<0.5,3.3,0) + if(abs(path-3)<0.5,3.3,0)
Sm1 injP iLH c1 0 SW
Bm2 c2 0 V=if(abs(path-4)<0.5,3.3,0)
Sm2 injP iRH c2 0 SW
Bm3 c3 0 V=if(abs(path-1)<0.5,3.3,0)
Sm3 injP iLF c3 0 SW
Bm4 c4 0 V=if(abs(path-2)<0.5,3.3,0)
Sm4 injN iRH c4 0 SW
Bm5 c5 0 V=if(abs(path-3)<0.5,3.3,0)
Sm5 injN iLF c5 0 SW
Bm6 c6 0 V=if(abs(path-1)<0.5,3.3,0) + if(abs(path-4)<0.5,3.3,0)
Sm6 injN iRF c6 0 SW
Bm7 c7 0 V=if(abs(path-2)<0.5,3.3,0) + if(abs(path-3)<0.5,3.3,0)
Sm7 sraw_p sLH c7 0 SW
Bm8 c8 0 V=if(abs(path-4)<0.5,3.3,0)
Sm8 sraw_p sRH c8 0 SW
Bm9 c9 0 V=if(abs(path-1)<0.5,3.3,0)
Sm9 sraw_p sLF c9 0 SW
Bm10 c10 0 V=if(abs(path-2)<0.5,3.3,0)
Sm10 sraw_n sRH c10 0 SW
Bm11 c11 0 V=if(abs(path-3)<0.5,3.3,0)
Sm11 sraw_n sLF c11 0 SW
Bm12 c12 0 V=if(abs(path-1)<0.5,3.3,0) + if(abs(path-4)<0.5,3.3,0)
Sm12 sraw_n sRF c12 0 SW
* --- sense lines: 1k protection, 1M bias to VREF ---
R6 sraw_p sa {r6}
R7 sraw_n sb {r7}
R8 sa vref {r8}
R9 sb vref {r9}
* --- 74HC4053 selector: selv=0 body, selv=3.3 across R5 ---
Vsel sel 0 PULSE(0 3.3 0.02 1u 1u 0.02 0.1)
Bch chi 0 V=V(sel)
Bcl clo 0 V=3.3-V(sel)
S1 inp sa clo 0 SW
S2 inp ret chi 0 SW
S3 inn sb clo 0 SW
S4 inn vref chi 0 SW
Bina ina 0 V=limit(V(vref)+{gain}*(V(inp)-V(inn))+{gain}*{cmrr}*((V(inp)+V(inn))/2-V(vref)),0.05,3.25)
R11 ina adc {r11}
C5 adc 0 {c5}
Radc adc 0 10Meg
* --- DC definition of floating nodes ---
Rd0 n1 vref 1G
Rd1 injP vref 1G
Rd2 injN vref 1G
Rd3 SH vref 1G
Rd4 PV vref 1G
Rd5 mT vref 1G
Rd6 sraw_p vref 1G
Rd7 sraw_n vref 1G
Rd8 LH vref 1G
Rd9 RH vref 1G
Rd10 LF vref 1G
Rd11 RF vref 1G
Rd12 mLH vref 1G
Rd13 mRH vref 1G
Rd14 mLF vref 1G
Rd15 mRF vref 1G
Rd16 iLH vref 1G
Rd17 iRH vref 1G
Rd18 iLF vref 1G
Rd19 iRF vref 1G
Rd20 sLH vref 1G
Rd21 sRH vref 1G
Rd22 sLF vref 1G
Rd23 sRF vref 1G
.tran 0 0.04 0 5u
.save V(adc) V(ina)
.meas TRAN amax MAX V(ina) FROM=0.008 TO=0.039
.meas TRAN amin MIN V(ina) FROM=0.008 TO=0.039
.step param fx list 1 1.1
.step param path list 1 2 3 4
.step param run 1 100 1
.meas TRAN vbody PP V(adc) FROM=0.008 TO=0.019
.meas TRAN vsens PP V(adc) FROM=0.028 TO=0.039
.meas TRAN zmeas PARAM 220*vbody/vsens
.save V(adc) I(R4)
.param r3=table(run,1,101251,2,104172,3,98876.3,4,96924.6,5,100903,6,97715.2,7,95507,8,95302.9,9,96127.2,10,104448,11,95812.6,12,102995,13,96378.2,14,104954,15,96131.9,16,104195,17,95154.3,18,101204,19,100836,20,102679,21,97563.1,22,95257.9,23,98152,24,103986,25,98128,26,95630.7,27,104686,28,98722.8,29,102507,30,99066.8,31,100686,32,102540,33,102066,34,97048.8,35,100836,36,103689,37,101985,38,101026,39,96258.8,40,96368.4,41,102313,42,100489,43,100493,44,100120,45,97973,46,98988.5,47,95990.4,48,101574,49,101874,50,103703,51,104218,52,96050.7,53,104842,54,103398,55,95859.2,56,104906,57,96951.8,58,103030,59,102173,60,102984,61,98231.7,62,100132,63,100389,64,100375,65,99164.6,66,96140.4,67,98940.5,68,104429,69,101937,70,100216,71,101060,72,96084,73,104168,74,103801,75,99452.5,76,97573.5,77,95444.9,78,103373,79,102340,80,96070.5,81,99967.1,82,98749.5,83,99855.2,84,100733,85,97252.8,86,103949,87,101118,88,95458.3,89,104508,90,96818.6,91,104863,92,103706,93,100503,94,102447,95,99896.7,96,97156.3,97,95021.1,98,103573,99,96920.4,100,100184)
.param r4=table(run,1,4886.69,2,4760.74,3,4616.83,4,4901.12,5,4786.33,6,4912.46,7,4565.07,8,4474.5,9,4759.51,10,4643.28,11,4891,12,4767.93,13,4822.38,14,4882.69,15,4925.41,16,4745.42,17,4915.42,18,4849.89,19,4662.7,20,4680.29,21,4496.71,22,4551.36,23,4480.25,24,4784.82,25,4760.58,26,4683.92,27,4615.35,28,4719.6,29,4519.68,30,4881.95,31,4680.63,32,4730.31,33,4502.61,34,4797.97,35,4912.55,36,4886.42,37,4556.34,38,4900.16,39,4525.25,40,4930.64,41,4585.78,42,4552.16,43,4814.55,44,4822.29,45,4863.28,46,4588.01,47,4806.91,48,4754.82,49,4649.42,50,4618.33,51,4882.24,52,4756.53,53,4813.06,54,4769.3,55,4821.13,56,4803.82,57,4581.61,58,4899.44,59,4716.37,60,4870.38,61,4805.27,62,4680.43,63,4626.66,64,4633.35,65,4770.28,66,4561.55,67,4881.22,68,4628.22,69,4609.21,70,4565.61,71,4717.31,72,4824.81,73,4766.48,74,4878.35,75,4547.9,76,4909.4,77,4888.39,78,4930.43,79,4750.08,80,4690.59,81,4685.79,82,4689.89,83,4635.47,84,4596.49,85,4720.58,86,4600.65,87,4588.46,88,4570.06,89,4900.76,90,4822.31,91,4673.24,92,4835.4,93,4884.49,94,4791.26,95,4569.55,96,4800.96,97,4557.02,98,4824.36,99,4508.96,100,4684.47)
.param r5=table(run,1,221.577,2,220.081,3,217.999,4,220.299,5,219.173,6,219.682,7,222.376,8,218.586,9,221.701,10,218.586,11,218.68,12,221.264,13,222.82,14,222.381,15,222.526,16,219.024,17,219.821,18,221.019,19,218.19,20,219.276,21,219.559,22,218.084,23,221.893,24,222.022,25,219.741,26,218.366,27,217.379,28,221.068,29,221.763,30,222.391,31,220.366,32,220.983,33,222.687,34,217.194,35,221.814,36,218.952,37,219.835,38,217.451,39,221.723,40,217.306,41,222.813,42,219.245,43,222.041,44,220.887,45,220.626,46,220.32,47,217.923,48,217.405,49,221.23,50,221.19,51,217.467,52,217.867,53,220.828,54,218.21,55,222.09,56,217.977,57,222.63,58,220.543,59,217.602,60,219.938,61,217.173,62,221.22,63,220.887,64,217.445,65,218.018,66,220.151,67,222.545,68,217.634,69,219.337,70,217.618,71,217.773,72,219.582,73,220.585,74,218.571,75,219.977,76,217.277,77,219.326,78,220.338,79,218.271,80,217.27,81,220.925,82,222.446,83,217.692,84,218.526,85,221.123,86,222.759,87,217.193,88,217.735,89,221.868,90,218.417,91,221.579,92,222.01,93,221.63,94,217.349,95,219.586,96,218.641,97,221.909,98,221.341,99,217.421,100,222.208)
.param r6=table(run,1,972.521,2,999.687,3,1031.63,4,968.055,5,1001.91,6,1048.04,7,1034.02,8,974.857,9,981.372,10,995.651,11,980.641,12,1049.68,13,964.799,14,974.658,15,973.067,16,1043.66,17,990.907,18,1014.18,19,979.264,20,1004.59,21,1027.18,22,997.435,23,1041.51,24,990.325,25,1036.24,26,1023.88,27,989.22,28,1005.92,29,981.093,30,981.053,31,1023.72,32,1030.23,33,970.236,34,974.502,35,1014.07,36,978.038,37,1047.51,38,1030.73,39,1042.24,40,980.087,41,1021.99,42,980.47,43,955.9,44,978.986,45,1000.9,46,982.009,47,988.42,48,973.665,49,996.673,50,976.411,51,1027.18,52,1039.16,53,972.124,54,1032.3,55,1000.89,56,1005.36,57,1024.49,58,984.882,59,973.669,60,1034.23,61,973.001,62,1025.21,63,1003.13,64,1040.09,65,1033.97,66,981.254,67,1040.4,68,1036.78,69,974.08,70,993.894,71,1049.15,72,1006.82,73,988.823,74,1024.56,75,973.089,76,979.875,77,1042.62,78,986.001,79,1019.85,80,1034.5,81,971.621,82,1021.84,83,958.79,84,959.85,85,998.221,86,960.544,87,1003.35,88,1023.96,89,1003.16,90,975.835,91,1043.34,92,989.123,93,962.091,94,1041.69,95,1000.76,96,1021,97,971.227,98,1049.71,99,1017.25,100,955.08)
.param r7=table(run,1,980.017,2,974.751,3,987.945,4,1038.41,5,1026.52,6,1001.55,7,961.241,8,968.75,9,1036.28,10,1015.72,11,1033.28,12,1043.92,13,1021.27,14,989.411,15,1046.99,16,965.513,17,1022.04,18,990.613,19,979.292,20,970.134,21,1020.96,22,951.507,23,1048.98,24,950.328,25,979.294,26,1042.25,27,965.337,28,960.703,29,1028.14,30,1023.6,31,1017.86,32,973.011,33,975.355,34,1046.07,35,1001.88,36,1043.91,37,1003.9,38,1004.18,39,964.187,40,1045.89,41,992.375,42,1010.22,43,1009.24,44,958.712,45,958.703,46,1042.71,47,1049.57,48,1039.75,49,991.312,50,1000.87,51,976.136,52,962.246,53,987.042,54,1022.81,55,1029.76,56,965.937,57,1035.3,58,985.512,59,956.303,60,996.116,61,1039.65,62,1034.91,63,1018.63,64,1043.57,65,969.646,66,974.016,67,1032.76,68,1016.48,69,979.19,70,1021.97,71,1046.66,72,978.461,73,1007.16,74,1013.5,75,966.195,76,1007.44,77,1009.45,78,973.394,79,961.594,80,1027.85,81,952.507,82,1023.63,83,1012.95,84,982.471,85,985.255,86,1003.03,87,959.042,88,972.124,89,980.045,90,1046.75,91,1049.7,92,978.616,93,1033.32,94,997.915,95,953.121,96,1030.42,97,957.433,98,1005.95,99,982.411,100,954.398)
.param r8=table(run,1,1.03736e+07,2,9.51179e+06,3,1.04787e+07,4,1.01416e+07,5,1.04092e+07,6,1.00212e+07,7,1.01038e+07,8,1.00671e+07,9,1.02971e+07,10,9.6011e+06,11,1.01199e+07,12,1.0343e+07,13,1.03253e+07,14,9.72718e+06,15,9.70782e+06,16,1.00145e+07,17,1.00233e+07,18,1.00583e+07,19,9.93074e+06,20,9.81656e+06,21,9.69557e+06,22,9.95817e+06,23,1.01119e+07,24,1.0287e+07,25,1.02577e+07,26,9.77298e+06,27,9.58189e+06,28,1.03179e+07,29,9.51272e+06,30,9.75312e+06,31,1.04972e+07,32,9.73377e+06,33,9.7003e+06,34,1.03977e+07,35,9.51513e+06,36,1.0004e+07,37,9.55695e+06,38,9.87907e+06,39,9.51326e+06,40,9.51511e+06,41,9.91491e+06,42,1.03224e+07,43,1.04837e+07,44,9.96231e+06,45,1.02863e+07,46,9.5848e+06,47,1.00598e+07,48,9.62322e+06,49,9.86565e+06,50,1.01815e+07,51,1.01972e+07,52,9.86187e+06,53,1.01236e+07,54,1.02469e+07,55,9.94105e+06,56,9.5392e+06,57,1.01988e+07,58,1.01334e+07,59,9.69078e+06,60,9.76382e+06,61,1.03549e+07,62,1.03112e+07,63,9.74634e+06,64,9.68643e+06,65,1.02043e+07,66,9.87338e+06,67,9.7333e+06,68,9.732e+06,69,9.67573e+06,70,1.02784e+07,71,9.53747e+06,72,9.86035e+06,73,1.00548e+07,74,9.88614e+06,75,9.88062e+06,76,1.02031e+07,77,1.00473e+07,78,9.68295e+06,79,9.76981e+06,80,9.54603e+06,81,9.58856e+06,82,9.83934e+06,83,1.02735e+07,84,1.02741e+07,85,9.74778e+06,86,9.61047e+06,87,1.02484e+07,88,9.99833e+06,89,1.01517e+07,90,1.02627e+07,91,9.79576e+06,92,9.7403e+06,93,1.00498e+07,94,9.76918e+06,95,9.8936e+06,96,9.92418e+06,97,9.74663e+06,98,9.67856e+06,99,9.95686e+06,100,9.65278e+06)
.param r9=table(run,1,9.50527e+06,2,9.6924e+06,3,1.009e+07,4,1.00697e+07,5,9.65106e+06,6,1.03965e+07,7,9.9792e+06,8,9.53899e+06,9,9.62914e+06,10,9.88058e+06,11,9.68714e+06,12,1.02771e+07,13,1.04206e+07,14,9.62491e+06,15,1.00065e+07,16,9.59155e+06,17,1.02308e+07,18,9.89608e+06,19,1.04991e+07,20,1.02065e+07,21,9.63693e+06,22,9.66292e+06,23,1.0166e+07,24,9.74548e+06,25,1.01357e+07,26,1.00722e+07,27,1.00679e+07,28,1.04239e+07,29,1.03713e+07,30,9.63952e+06,31,9.65667e+06,32,9.77791e+06,33,1.04915e+07,34,1.01359e+07,35,1.03907e+07,36,9.59652e+06,37,9.92878e+06,38,9.85028e+06,39,9.76363e+06,40,9.6614e+06,41,1.02793e+07,42,1.04365e+07,43,9.9598e+06,44,1.03802e+07,45,9.56592e+06,46,9.70671e+06,47,1.00217e+07,48,1.00332e+07,49,9.99341e+06,50,9.70112e+06,51,9.87948e+06,52,9.99466e+06,53,1.04264e+07,54,1.01974e+07,55,9.85335e+06,56,1.04438e+07,57,9.81565e+06,58,1.03642e+07,59,9.70019e+06,60,9.98097e+06,61,1.0129e+07,62,1.0169e+07,63,1.02071e+07,64,9.918e+06,65,9.66181e+06,66,1.0002e+07,67,9.53185e+06,68,1.00669e+07,69,1.04044e+07,70,9.51699e+06,71,1.04443e+07,72,1.02534e+07,73,1.0405e+07,74,1.0276e+07,75,9.56394e+06,76,1.02738e+07,77,1.03181e+07,78,9.82334e+06,79,9.94814e+06,80,1.02458e+07,81,9.67924e+06,82,1.03403e+07,83,1.04075e+07,84,9.5216e+06,85,9.79686e+06,86,9.68979e+06,87,9.84072e+06,88,9.82851e+06,89,9.65135e+06,90,9.94867e+06,91,1.01541e+07,92,1.03706e+07,93,1.01782e+07,94,9.53019e+06,95,9.78446e+06,96,1.04901e+07,97,1.00192e+07,98,1.01095e+07,99,1.04352e+07,100,1.01057e+07)
.param r11=table(run,1,1548.18,2,1528.8,3,1515.76,4,1481.44,5,1565.01,6,1536.42,7,1514.2,8,1513.56,9,1540.03,10,1445.06,11,1490.22,12,1484.25,13,1443.51,14,1429.95,15,1499.61,16,1569.81,17,1437.71,18,1536.64,19,1477.88,20,1540.58,21,1473.21,22,1465.45,23,1526.76,24,1446.37,25,1536.06,26,1501.01,27,1568.04,28,1440.19,29,1449.35,30,1490.68,31,1546.93,32,1470.59,33,1467.99,34,1438.98,35,1435.03,36,1431.88,37,1524.04,38,1435.41,39,1445.17,40,1457,41,1451.35,42,1474.33,43,1540.43,44,1514.72,45,1569.77,46,1437.58,47,1567.18,48,1432.51,49,1467.18,50,1434.17,51,1473.31,52,1442.68,53,1470.28,54,1549.5,55,1500.86,56,1475.68,57,1483.67,58,1476.12,59,1487.23,60,1475.31,61,1508.84,62,1533.17,63,1535.2,64,1481.05,65,1557.26,66,1526.15,67,1492.77,68,1471.23,69,1558.11,70,1566.33,71,1504.72,72,1495.47,73,1549.07,74,1559.63,75,1495.55,76,1482.49,77,1518.81,78,1552.75,79,1442.17,80,1528.73,81,1553.59,82,1482.86,83,1479.75,84,1497.4,85,1432.47,86,1539.62,87,1546.12,88,1460.42,89,1517.52,90,1445.43,91,1483.5,92,1562.91,93,1449,94,1542.28,95,1520.12,96,1519.71,97,1512.94,98,1468.09,99,1519,100,1542.2)
.param c2=table(run,1,1.11883e-06,2,8.80243e-07,3,1.0552e-06,4,9.64382e-07,5,8.02072e-07,6,1.03226e-06,7,1.06371e-06,8,8.66404e-07,9,1.15305e-06,10,1.06498e-06,11,1.15357e-06,12,1.05649e-06,13,8.36724e-07,14,1.00133e-06,15,1.16598e-06,16,1.03015e-06,17,1.02512e-06,18,9.52172e-07,19,9.78952e-07,20,8.22683e-07,21,1.1073e-06,22,1.11698e-06,23,1.02806e-06,24,1.1198e-06,25,9.51305e-07,26,8.30043e-07,27,1.03176e-06,28,8.99808e-07,29,9.823e-07,30,1.04099e-06,31,9.64437e-07,32,1.10428e-06,33,1.04212e-06,34,9.2722e-07,35,8.51632e-07,36,1.19617e-06,37,8.22683e-07,38,9.03351e-07,39,8.75451e-07,40,8.34556e-07,41,1.05585e-06,42,1.02788e-06,43,8.38904e-07,44,8.21316e-07,45,1.15079e-06,46,1.08476e-06,47,9.13616e-07,48,1.17568e-06,49,8.9684e-07,50,1.11638e-06,51,9.95313e-07,52,9.27499e-07,53,9.58084e-07,54,9.19137e-07,55,8.77897e-07,56,8.75834e-07,57,9.76273e-07,58,8.76279e-07,59,9.28679e-07,60,1.10686e-06,61,8.89047e-07,62,8.62851e-07,63,1.08879e-06,64,8.66887e-07,65,8.80528e-07,66,1.18889e-06,67,8.25272e-07,68,1.16768e-06,69,9.44007e-07,70,8.98893e-07,71,8.50282e-07,72,1.03861e-06,73,1.09488e-06,74,9.91678e-07,75,1.07845e-06,76,8.8807e-07,77,1.06983e-06,78,8.01302e-07,79,8.42396e-07,80,8.50501e-07,81,1.08673e-06,82,1.19532e-06,83,1.17505e-06,84,1.04112e-06,85,9.0203e-07,86,8.26438e-07,87,8.38222e-07,88,1.17407e-06,89,8.26427e-07,90,9.07619e-07,91,9.86033e-07,92,9.46866e-07,93,9.88792e-07,94,9.35117e-07,95,1.12471e-06,96,1.10263e-06,97,1.15086e-06,98,1.00518e-06,99,1.12426e-06,100,9.91937e-07)
.param c3=table(run,1,9.87174e-07,2,9.47815e-07,3,1.07058e-06,4,8.95796e-07,5,1.10119e-06,6,9.7066e-07,7,9.22664e-07,8,1.07115e-06,9,8.78913e-07,10,1.13222e-06,11,9.5015e-07,12,8.73778e-07,13,1.19515e-06,14,8.49253e-07,15,8.16212e-07,16,1.12147e-06,17,1.02324e-06,18,9.86648e-07,19,9.48651e-07,20,1.09313e-06,21,9.95231e-07,22,8.73627e-07,23,1.18097e-06,24,1.07453e-06,25,1.08997e-06,26,8.4995e-07,27,1.05885e-06,28,8.69472e-07,29,1.0647e-06,30,1.17424e-06,31,1.11332e-06,32,9.49673e-07,33,1.19625e-06,34,8.11173e-07,35,1.07723e-06,36,1.03167e-06,37,9.01061e-07,38,1.04925e-06,39,1.03333e-06,40,9.88785e-07,41,1.08754e-06,42,8.0236e-07,43,1.1494e-06,44,9.76031e-07,45,9.21187e-07,46,9.17257e-07,47,1.19977e-06,48,8.68625e-07,49,8.59387e-07,50,1.12358e-06,51,1.01221e-06,52,9.10112e-07,53,8.08895e-07,54,1.06898e-06,55,9.22995e-07,56,8.40717e-07,57,9.17363e-07,58,8.01116e-07,59,9.45021e-07,60,1.13268e-06,61,1.15004e-06,62,1.0797e-06,63,8.2738e-07,64,1.06466e-06,65,1.09254e-06,66,1.14106e-06,67,1.18421e-06,68,9.36846e-07,69,1.07729e-06,70,9.1688e-07,71,1.12823e-06,72,9.69072e-07,73,1.16951e-06,74,1.16644e-06,75,1.06056e-06,76,1.14094e-06,77,8.63041e-07,78,1.11439e-06,79,1.06091e-06,80,1.01007e-06,81,1.09999e-06,82,1.15836e-06,83,9.1875e-07,84,8.19848e-07,85,1.18125e-06,86,9.53084e-07,87,9.9759e-07,88,1.003e-06,89,8.05434e-07,90,1.19247e-06,91,9.84767e-07,92,1.14982e-06,93,1.07997e-06,94,1.0054e-06,95,1.04578e-06,96,8.08238e-07,97,1.1419e-06,98,9.83729e-07,99,1.10493e-06,100,1.0455e-06)
.param c4=table(run,1,9.21213e-07,2,8.01494e-07,3,8.60315e-07,4,8.15223e-07,5,1.12421e-06,6,1.15128e-06,7,1.18454e-06,8,8.0843e-07,9,1.02946e-06,10,9.50742e-07,11,1.08435e-06,12,1.1038e-06,13,8.46703e-07,14,8.70522e-07,15,9.2614e-07,16,9.12769e-07,17,1.17285e-06,18,1.10218e-06,19,1.03257e-06,20,1.12697e-06,21,1.16927e-06,22,1.04685e-06,23,1.04314e-06,24,8.84966e-07,25,1.07937e-06,26,1.15391e-06,27,9.29452e-07,28,1.13966e-06,29,1.00315e-06,30,8.58361e-07,31,1.15671e-06,32,9.29276e-07,33,1.18003e-06,34,8.87676e-07,35,1.12486e-06,36,8.21797e-07,37,8.07334e-07,38,8.39036e-07,39,9.68918e-07,40,1.03698e-06,41,1.00654e-06,42,9.48865e-07,43,1.03282e-06,44,9.53845e-07,45,8.51146e-07,46,1.16007e-06,47,1.16479e-06,48,9.64009e-07,49,9.7609e-07,50,1.06627e-06,51,1.07779e-06,52,1.08532e-06,53,1.07869e-06,54,1.00692e-06,55,9.2215e-07,56,1.06086e-06,57,9.68577e-07,58,8.54988e-07,59,1.12675e-06,60,8.56467e-07,61,1.10429e-06,62,9.01783e-07,63,1.17846e-06,64,1.1128e-06,65,1.13548e-06,66,9.71997e-07,67,8.03275e-07,68,8.78503e-07,69,9.9611e-07,70,1.13296e-06,71,9.73186e-07,72,1.02281e-06,73,8.26465e-07,74,8.51048e-07,75,1.1901e-06,76,8.48837e-07,77,1.04178e-06,78,1.06697e-06,79,1.09678e-06,80,1.07574e-06,81,9.77692e-07,82,1.06365e-06,83,1.17595e-06,84,9.17589e-07,85,8.03239e-07,86,8.76662e-07,87,8.39906e-07,88,1.06019e-06,89,1.08621e-06,90,1.11643e-06,91,9.11406e-07,92,9.52557e-07,93,1.11898e-06,94,8.77896e-07,95,1.06558e-06,96,8.45125e-07,97,1.1875e-06,98,1.02541e-06,99,1.18148e-06,100,1.05702e-06)
.param c5=table(run,1,9.55685e-09,2,1.06601e-08,3,9.88063e-09,4,1.07524e-08,5,9.27353e-09,6,9.82329e-09,7,9.93168e-09,8,9.62114e-09,9,1.02775e-08,10,9.74345e-09,11,9.19362e-09,12,1.05154e-08,13,9.35362e-09,14,1.0721e-08,15,1.01999e-08,16,1.06036e-08,17,9.07921e-09,18,1.00073e-08,19,1.08958e-08,20,9.89039e-09,21,1.03128e-08,22,9.81262e-09,23,9.67145e-09,24,9.53516e-09,25,9.77498e-09,26,9.9483e-09,27,1.01422e-08,28,1.08206e-08,29,9.3308e-09,30,1.04247e-08,31,1.0984e-08,32,1.02726e-08,33,9.0847e-09,34,9.05087e-09,35,1.05731e-08,36,1.00225e-08,37,1.00801e-08,38,1.03388e-08,39,9.85846e-09,40,9.63664e-09,41,1.07464e-08,42,1.09214e-08,43,1.07765e-08,44,1.01648e-08,45,1.07713e-08,46,1.07873e-08,47,9.72781e-09,48,1.00936e-08,49,9.58652e-09,50,9.64286e-09,51,1.02758e-08,52,1.09725e-08,53,9.88714e-09,54,9.67569e-09,55,1.09768e-08,56,9.9223e-09,57,1.05424e-08,58,1.07024e-08,59,9.04272e-09,60,9.32885e-09,61,1.00259e-08,62,9.51567e-09,63,1.01537e-08,64,1.05194e-08,65,9.50989e-09,66,9.90327e-09,67,9.65096e-09,68,9.08642e-09,69,9.56157e-09,70,1.07884e-08,71,1.04264e-08,72,1.07947e-08,73,1.05392e-08,74,9.33238e-09,75,1.07716e-08,76,9.13004e-09,77,9.713e-09,78,9.03803e-09,79,9.74138e-09,80,9.67097e-09,81,9.20554e-09,82,1.06629e-08,83,1.08377e-08,84,1.0813e-08,85,1.04549e-08,86,1.07005e-08,87,1.05607e-08,88,1.04088e-08,89,9.68542e-09,90,9.13976e-09,91,9.03813e-09,92,9.89582e-09,93,1.06116e-08,94,1.0214e-08,95,1.02278e-08,96,1.0423e-08,97,1.07685e-08,98,1.08428e-08,99,9.13364e-09,100,9.03859e-09)
.param gain=table(run,1,9.97549,2,9.96545,3,9.97396,4,9.99677,5,9.99189,6,10.0423,7,10.0128,8,10.0438,9,10.0109,10,10.004,11,10.0227,12,10.0221,13,10.0075,14,9.99842,15,9.95664,16,10.0203,17,9.99528,18,9.9838,19,10.0389,20,9.95625,21,10.0121,22,9.99176,23,10.0013,24,10.0439,25,9.95265,26,10.0305,27,10.0252,28,9.95443,29,9.96391,30,9.99755,31,9.9766,32,9.96866,33,10.0021,34,9.96262,35,9.99524,36,10.0004,37,9.98815,38,10.0462,39,9.97056,40,9.96086,41,9.99686,42,9.96188,43,10.0287,44,10.0087,45,9.99799,46,10.0436,47,9.98272,48,10.0219,49,10.0337,50,10.0158,51,10.0178,52,9.98628,53,10.0298,54,9.98268,55,9.98352,56,9.95117,57,9.95757,58,10.0125,59,9.96034,60,9.98837,61,9.9661,62,9.96201,63,9.97723,64,10.0175,65,9.95928,66,9.99157,67,9.97033,68,9.98425,69,9.98496,70,10.0236,71,10.0327,72,9.97674,73,9.99636,74,10.0264,75,10.0134,76,9.97316,77,9.95756,78,9.95695,79,9.98899,80,10.0004,81,9.99653,82,10.0044,83,9.9655,84,10.0494,85,10.0289,86,9.95824,87,10.006,88,10.0321,89,10.0197,90,10.0207,91,10.0267,92,10.0066,93,9.97171,94,9.98972,95,9.97562,96,10.0443,97,9.99503,98,10.031,99,9.98841,100,9.97463)
.param amp=table(run,1,0.822706,2,0.799137,3,0.817052,4,0.836326,5,0.871866,6,0.772725,7,0.847958,8,0.835099,9,0.776381,10,0.79216,11,0.866716,12,0.822669,13,0.822865,14,0.787996,15,0.795014,16,0.849081,17,0.847406,18,0.873402,19,0.813684,20,0.854291,21,0.865549,22,0.872077,23,0.766078,24,0.799262,25,0.891475,26,0.772442,27,0.841857,28,0.807745,29,0.801386,30,0.781091,31,0.82375,32,0.777733,33,0.843453,34,0.847691,35,0.787113,36,0.82142,37,0.83049,38,0.893847,39,0.851857,40,0.871295,41,0.825338,42,0.879113,43,0.879035,44,0.889937,45,0.780183,46,0.797614,47,0.780408,48,0.888094,49,0.8762,50,0.774739,51,0.814605,52,0.868608,53,0.794629,54,0.784246,55,0.793994,56,0.858576,57,0.800329,58,0.895157,59,0.870876,60,0.825124,61,0.792263,62,0.81631,63,0.821253,64,0.765923,65,0.84144,66,0.79533,67,0.765418,68,0.894999,69,0.891773,70,0.807798,71,0.835052,72,0.832531,73,0.86344,74,0.804177,75,0.882804,76,0.829016,77,0.781288,78,0.861216,79,0.791169,80,0.893204,81,0.878205,82,0.860954,83,0.877913,84,0.876521,85,0.817345,86,0.808297,87,0.794767,88,0.798556,89,0.867177,90,0.813537,91,0.856024,92,0.792989,93,0.874186,94,0.870717,95,0.813572,96,0.847029,97,0.782442,98,0.818732,99,0.889708,100,0.896102)
.param cmrr=table(run,1,-0.000279578,2,0.000131725,3,0.000107689,4,-0.000476252,5,0.000235255,6,-0.000371538,7,-0.000867231,8,-0.000154317,9,-0.00023337,10,0.000565706,11,0.000211738,12,0.00041862,13,0.000644826,14,0.000213863,15,0.000131566,16,-0.000112057,17,-0.000843022,18,0.000415946,19,-0.000130497,20,-0.000567331,21,-0.000453066,22,0.000690375,23,-0.000202339,24,0.000198424,25,0.00062411,26,0.000254207,27,-0.000281533,28,0.000641956,29,0.000607373,30,-0.000106498,31,-0.000113308,32,0.000200848,33,-0.000461414,34,0.000793519,35,0.000140806,36,-0.000111872,37,0.000220391,38,-0.00012905,39,-0.00039889,40,-0.000156866,41,0.000120401,42,-0.000222584,43,-0.00019252,44,-0.000459099,45,-0.000566475,46,-0.000998489,47,-0.000651914,48,0.0001835,49,-0.000240358,50,-0.000217516,51,-0.000451453,52,0.000723867,53,-0.000212279,54,0.000322452,55,0.000726805,56,0.000553759,57,-0.000210754,58,-0.000852193,59,-0.000364008,60,0.00011058,61,0.000466525,62,-0.000955262,63,0.00030355,64,0.00058939,65,-0.00033165,66,-0.000111747,67,0.000839364,68,-0.000604868,69,-0.000263836,70,-0.000344475,71,-0.000150497,72,-0.000205482,73,0.000340927,74,-0.000259797,75,0.000158901,76,-0.000114246,77,0.000546381,78,-0.000212241,79,0.000262804,80,0.000231376,81,0.000233433,82,0.000750284,83,-0.000198409,84,0.000676553,85,-0.000601336,86,0.000139238,87,0.000207972,88,0.00083446,89,-0.000242198,90,0.000190588,91,0.00070258,92,0.000540195,93,-0.000214443,94,0.00021561,95,0.000113234,96,0.000122224,97,-0.000590524,98,0.000152289,99,0.000112772,100,-0.000466888)
.param sz=table(run,1,1.39685,2,1.05685,3,0.850503,4,1.22593,5,1.25512,6,1.06366,7,0.988062,8,1.16062,9,1.27672,10,0.930897,11,0.959513,12,0.99384,13,1.3401,14,0.886105,15,1.23267,16,1.00344,17,1.11526,18,1.29131,19,1.04568,20,1.15035,21,0.879906,22,1.34667,23,0.994736,24,0.790687,25,1.21157,26,1.30572,27,0.838701,28,1.02867,29,0.791074,30,1.18704,31,0.961012,32,1.22951,33,0.929536,34,0.809034,35,1.38439,36,1.36414,37,0.82116,38,1.26463,39,1.02439,40,1.09347,41,0.921389,42,0.905726,43,0.837887,44,0.985667,45,0.985485,46,0.971324,47,0.706285,48,0.943158,49,1.3316,50,1.10334,51,1.12527,52,1.10594,53,1.02503,54,0.958102,55,1.37606,56,1.24639,57,1.15215,58,0.956211,59,0.887122,60,1.35918,61,0.742739,62,1.15989,63,0.873571,64,1.06022,65,1.24693,66,0.748062,67,1.32996,68,1.02064,69,1.36157,70,1.28422,71,1.18583,72,0.760753,73,1.27721,74,1.04795,75,0.899136,76,1.2102,77,1.23573,78,0.919445,79,1.35352,80,1.0514,81,0.961935,82,1.39201,83,1.28829,84,1.23491,85,1.16763,86,1.18084,87,0.935439,88,1.02707,89,1.29272,90,0.906812,91,0.865925,92,0.886656,93,1.29609,94,1.20521,95,0.826841,96,0.741423,97,1.13548,98,1.30237,99,0.829403,100,1.36264)
.param ibp=table(run,1,2.08532e-08,2,2.1943e-08,3,1.84353e-08,4,5.50394e-09,5,1.52601e-08,6,2.40188e-08,7,2.02806e-08,8,1.7215e-08,9,2.10703e-08,10,1.41485e-08,11,6.28424e-09,12,5.66678e-09,13,9.3439e-09,14,1.55387e-08,15,2.15796e-08,16,1.33018e-08,17,9.44394e-09,18,2.07048e-08,19,1.87108e-08,20,1.25325e-08,21,1.37524e-08,22,2.28698e-08,23,2.20296e-08,24,2.13007e-08,25,1.05737e-08,26,2.23413e-08,27,1.66545e-08,28,2.34318e-08,29,1.42959e-08,30,7.57717e-09,31,2.38042e-08,32,1.09273e-08,33,5.08568e-09,34,2.30562e-08,35,9.88271e-09,36,7.49935e-09,37,2.3133e-08,38,8.55907e-09,39,2.30885e-08,40,7.75484e-09,41,1.89054e-08,42,2.05632e-08,43,1.03162e-08,44,1.72703e-08,45,1.78048e-08,46,2.42513e-08,47,2.28015e-08,48,6.50679e-09,49,1.21832e-08,50,1.73441e-08,51,1.41907e-08,52,1.36543e-08,53,8.77211e-09,54,1.34303e-08,55,2.20662e-08,56,1.47721e-08,57,1.94997e-08,58,2.09142e-08,59,1.58464e-08,60,2.43408e-08,61,1.31275e-08,62,1.99621e-08,63,1.02993e-08,64,1.90568e-08,65,1.42622e-08,66,9.09895e-09,67,1.87526e-08,68,2.44421e-08,69,1.09519e-08,70,1.21462e-08,71,2.32028e-08,72,2.42402e-08,73,5.7036e-09,74,7.91571e-09,75,1.55341e-08,76,1.62794e-08,77,7.44797e-09,78,2.22258e-08,79,5.8116e-09,80,6.31995e-09,81,8.00173e-09,82,2.10042e-08,83,1.57333e-08,84,1.40173e-08,85,1.91565e-08,86,1.90666e-08,87,2.21066e-08,88,8.40012e-09,89,1.81774e-08,90,7.6033e-09,91,1.69226e-08,92,1.02014e-08,93,1.31094e-08,94,1.0023e-08,95,5.21152e-09,96,2.2833e-08,97,1.02893e-08,98,2.04795e-08,99,6.20491e-09,100,1.48455e-08)
.param ibn=table(run,1,1.74436e-08,2,1.77943e-08,3,1.10084e-08,4,1.24437e-08,5,1.9517e-08,6,1.002e-08,7,2.13044e-08,8,8.82505e-09,9,1.15434e-08,10,6.63063e-09,11,1.53755e-08,12,2.18864e-08,13,2.03822e-08,14,1.06591e-08,15,2.02214e-08,16,1.88424e-08,17,8.91098e-09,18,1.39458e-08,19,6.46583e-09,20,1.77433e-08,21,1.47849e-08,22,1.83664e-08,23,2.01105e-08,24,7.3518e-09,25,1.43857e-08,26,5.11445e-09,27,1.48187e-08,28,6.40346e-09,29,1.21302e-08,30,2.31151e-08,31,1.31178e-08,32,1.77208e-08,33,5.70473e-09,34,1.1709e-08,35,2.23215e-08,36,8.03441e-09,37,2.42016e-08,38,2.44031e-08,39,9.92711e-09,40,1.58382e-08,41,1.31871e-08,42,1.07856e-08,43,1.14957e-08,44,2.27278e-08,45,2.33073e-08,46,2.02748e-08,47,1.69623e-08,48,1.91481e-08,49,1.60943e-08,50,1.39397e-08,51,1.6256e-08,52,1.07637e-08,53,1.3058e-08,54,2.20334e-08,55,1.79412e-08,56,1.57116e-08,57,7.10524e-09,58,1.82241e-08,59,9.43127e-09,60,1.95951e-08,61,1.39743e-08,62,2.0511e-08,63,1.22718e-08,64,1.27285e-08,65,1.49406e-08,66,1.82396e-08,67,1.24e-08,68,5.13428e-09,69,2.11788e-08,70,2.11061e-08,71,1.04027e-08,72,1.49752e-08,73,1.08225e-08,74,2.00847e-08,75,2.45974e-08,76,1.54244e-08,77,5.27638e-09,78,9.20314e-09,79,2.31745e-08,80,7.42343e-09,81,1.75326e-08,82,7.84885e-09,83,1.51354e-08,84,8.41289e-09,85,1.96914e-08,86,2.48238e-08,87,1.25996e-08,88,5.40864e-09,89,2.35456e-08,90,5.394e-09,91,2.37325e-08,92,1.53104e-08,93,2.33928e-08,94,6.27703e-09,95,2.42292e-08,96,2.25463e-08,97,2.13365e-08,98,1.60278e-08,99,2.29093e-08,100,9.45113e-09)
.param rciLH=table(run,1,9577.31,2,3641.47,3,6110.27,4,225.213,5,484.972,6,4682.38,7,3477.44,8,1891.95,9,3371.06,10,3801.01,11,3871.97,12,1669.17,13,260.547,14,1506.51,15,3187.33,16,5245.22,17,6221.56,18,3252.45,19,5933.15,20,549.027,21,348.187,22,242.683,23,746.53,24,1505.8,25,5780.35,26,1539.63,27,382.78,28,390.866,29,1986.28,30,299.353,31,866.456,32,228.52,33,1720.13,34,735.837,35,965.868,36,984.784,37,1375.98,38,442.029,39,3326.76,40,2347.32,41,7767.61,42,6626.65,43,2021.42,44,3167.72,45,4589.72,46,252.575,47,2770.01,48,8980.4,49,1134.03,50,482.578,51,214.204,52,4978.42,53,3688.38,54,2876.73,55,1066.26,56,1196.18,57,405.624,58,259.598,59,5745.91,60,2828.91,61,614.851,62,331.103,63,4244.22,64,1159.63,65,1345.48,66,2007.61,67,5380.49,68,634.357,69,312.5,70,4262.27,71,4315.32,72,522.216,73,1351.8,74,3636.65,75,2081.48,76,3013.88,77,9882.54,78,1062.52,79,9640.75,80,5577.8,81,1333.5,82,516.683,83,840.626,84,1312.32,85,1369.18,86,219.19,87,7984.54,88,7303.75,89,6679.61,90,635.903,91,1266.37,92,296.333,93,6284.28,94,6252.51,95,5774.03,96,2341.3,97,438.671,98,6745.14,99,999.394,100,201.899)
.param rcsLH=table(run,1,464.337,2,286.074,3,2667.55,4,323.46,5,434.822,6,2820.55,7,311.431,8,233.591,9,5949.79,10,1926.75,11,421.947,12,910.778,13,1274.46,14,2338.24,15,5554.35,16,741.847,17,433.668,18,228.801,19,680.375,20,1290.19,21,1124.19,22,2678.99,23,270.83,24,229.543,25,1154.23,26,847.145,27,2254.11,28,1344.24,29,600.115,30,287.379,31,3859.26,32,972.648,33,269.129,34,280.581,35,676.073,36,5224.15,37,1235.13,38,5991.28,39,670.87,40,1068.28,41,8158.02,42,276.462,43,2332.1,44,1261.97,45,375.473,46,3123.77,47,3520.58,48,213.767,49,2545.72,50,3421.95,51,1407.52,52,3708.33,53,419.228,54,2862.54,55,432.649,56,2815.16,57,669.851,58,961.755,59,5023.99,60,575.992,61,899.392,62,2455.94,63,1107.22,64,5362.74,65,1184.03,66,594.899,67,4517.18,68,4968.18,69,3523.19,70,1251.09,71,6087.38,72,3917.23,73,5593.8,74,352.961,75,1452.29,76,2319.41,77,680.393,78,313.631,79,775.097,80,3653.28,81,773.105,82,1896.23,83,5902.88,84,7395.65,85,8907.12,86,2694.86,87,639.471,88,2320.49,89,236.9,90,5790.67,91,438.763,92,4235.17,93,4713.73,94,7774.49,95,2154.34,96,1073.23,97,1037.36,98,1370.43,99,1460.74,100,468.427)
.param rciRH=table(run,1,374.305,2,1661.18,3,334.689,4,8793.99,5,827.888,6,3306.26,7,7125.13,8,4602.92,9,6578.42,10,645.953,11,566.708,12,1706.53,13,227.167,14,1629.41,15,2876.33,16,2746.36,17,1182.65,18,918.937,19,1384.26,20,1557.53,21,2443.83,22,2094.13,23,335.485,24,1720.27,25,617.084,26,3911.28,27,4886.76,28,1553.64,29,228.373,30,731.687,31,1263.59,32,1918.51,33,441.611,34,4500.82,35,1443.02,36,2294.92,37,5774.22,38,6201.7,39,6616.58,40,5870.94,41,224.936,42,318.563,43,7647.56,44,4841.2,45,1294.22,46,7229.25,47,236.326,48,4141.78,49,8543.82,50,1229.06,51,472.878,52,337.821,53,284.451,54,9394.96,55,303.016,56,9618.05,57,602.017,58,2422.97,59,704.442,60,859.328,61,734.057,62,5312.09,63,232.629,64,219.298,65,978.024,66,7814.26,67,717.206,68,290.854,69,4694.27,70,6671.91,71,802.142,72,4860.46,73,575.186,74,552.553,75,4351.53,76,745.44,77,1469.43,78,2500.61,79,3421.02,80,5246.03,81,549.854,82,3952.95,83,6791.55,84,6186.66,85,5927.53,86,3687.15,87,9406.54,88,1011.63,89,569.843,90,6534.38,91,2048.29,92,396.284,93,884.177,94,2479.25,95,4885.95,96,3152.94,97,472.382,98,302.723,99,7793.53,100,703.484)
.param rcsRH=table(run,1,2196.43,2,1457.87,3,5454.89,4,2621.48,5,403.492,6,2348.22,7,4609.63,8,8553.85,9,376.214,10,270.881,11,1628.85,12,3365.7,13,682.629,14,940.047,15,3555.77,16,453.084,17,3764.83,18,5790.43,19,433.972,20,2361.04,21,340.099,22,4101.9,23,411.247,24,5488.01,25,660.77,26,266.334,27,339.266,28,3695,29,730.426,30,7845.03,31,1154.8,32,538.99,33,736.629,34,2819.52,35,206.494,36,3475.28,37,621.521,38,2278.42,39,934.457,40,919.825,41,9788.42,42,3760.78,43,210.203,44,1335.21,45,1370.25,46,8813.68,47,286.476,48,398.373,49,343.991,50,3693.25,51,904.719,52,627.8,53,1222.6,54,468.931,55,300.035,56,4535.15,57,3843.76,58,2947.84,59,220.117,60,202.11,61,873.499,62,230.219,63,1173.06,64,571.945,65,375.32,66,992.388,67,5501.05,68,7554.01,69,5294.46,70,900.155,71,995.238,72,2357.4,73,5005.05,74,4583.52,75,678.759,76,287.459,77,454.877,78,281.113,79,5039.83,80,1919.46,81,3044.38,82,358.037,83,374.792,84,925.201,85,1877.67,86,3733.83,87,255.38,88,341.072,89,915.448,90,2895.47,91,8468.4,92,1135.84,93,1579.2,94,7363.31,95,2044.84,96,519.323,97,5795.69,98,579.912,99,471.883,100,1115.3)
.param rciLF=table(run,1,237.512,2,6045.18,3,8062.48,4,1067.98,5,774.423,6,8947.1,7,6197.28,8,5648.92,9,222.022,10,3959.6,11,3736.14,12,889.448,13,678.423,14,4411.63,15,650.901,16,1731.22,17,3182.27,18,1930.41,19,1035.17,20,442.798,21,343.204,22,461.661,23,656.716,24,278.241,25,270.321,26,563.809,27,1686.07,28,1108.27,29,3837.6,30,227.582,31,905.805,32,780.974,33,263.487,34,1700.56,35,1130.29,36,1904.3,37,4628.95,38,1537.14,39,1443.06,40,1475.75,41,2132.05,42,1159.23,43,426.262,44,8670.15,45,9596.91,46,3292.1,47,1413.31,48,1209.14,49,8733.55,50,831.306,51,266.91,52,4935.65,53,500.581,54,1458.58,55,783.812,56,262.079,57,9741.98,58,1170.68,59,6443.93,60,5202.31,61,2252.92,62,426.145,63,439.682,64,621.758,65,634.971,66,2060.85,67,7586.63,68,5235.02,69,9070.18,70,3759.36,71,738.694,72,7203.82,73,520.599,74,7093.86,75,5163.56,76,438.925,77,452.661,78,403.612,79,2554.31,80,1903.94,81,693.669,82,8572.84,83,4101.31,84,256.25,85,2886.31,86,3266.86,87,3540.33,88,3929.78,89,536.425,90,3729.64,91,5968.49,92,2463.01,93,393.689,94,3169.59,95,6890.95,96,2724.84,97,2256.37,98,2618.94,99,8830.14,100,1150.17)
.param rcsLF=table(run,1,229.959,2,821.877,3,6866.85,4,1551.85,5,8163.27,6,734.93,7,1549.2,8,243.884,9,2551.13,10,333.987,11,6672.74,12,5155.41,13,3340.88,14,6095,15,385.342,16,4053.5,17,1743.17,18,1773.21,19,5103.41,20,8620.37,21,394.619,22,8332.08,23,1151.72,24,584.768,25,472.023,26,4804.92,27,3528.11,28,347.39,29,544.116,30,7261.67,31,1087.3,32,2170.88,33,225.663,34,2243.08,35,436.584,36,454.894,37,615.399,38,438.073,39,6185.75,40,312.576,41,266.996,42,356.095,43,824.255,44,603.932,45,280.974,46,5851.04,47,243.457,48,1545.16,49,2704.53,50,281.956,51,2612.67,52,9708.26,53,4582.92,54,287.221,55,983.474,56,1385.75,57,2894.82,58,417.562,59,643.375,60,588.966,61,1399.52,62,570.129,63,209.951,64,9721.6,65,563.732,66,285.549,67,2260.52,68,350.002,69,3227.7,70,2443.12,71,204.532,72,283.196,73,654.748,74,6015.71,75,215.05,76,4273.94,77,965.009,78,4009,79,619.256,80,1593.92,81,1903.62,82,774.059,83,587.646,84,6777.09,85,585.981,86,265.288,87,625.333,88,1609.13,89,399.543,90,428.251,91,6734.89,92,343.185,93,3901.07,94,2139.46,95,518.163,96,3023.82,97,2359.26,98,881.362,99,943.532,100,1708.64)
.param rciRF=table(run,1,1499.03,2,2076.48,3,1857.66,4,6080.04,5,1884.1,6,949.923,7,7188.98,8,752.321,9,463.189,10,336.778,11,327.085,12,7297.44,13,1186.02,14,403.438,15,3857.83,16,258.225,17,4700.85,18,2694.02,19,5094.04,20,619.822,21,605.901,22,6406.97,23,7545.16,24,3983.09,25,577.606,26,1255.43,27,967.709,28,797.638,29,973.522,30,2188.47,31,345.602,32,2010.24,33,7513.46,34,296.192,35,3246.93,36,4902.18,37,3343.71,38,1526.13,39,2779.91,40,1813.37,41,1397.88,42,1490.52,43,4906.81,44,329.204,45,1475.06,46,5383.4,47,1438.33,48,2212.7,49,4499.77,50,1669.74,51,6593.2,52,2188.07,53,4892.23,54,929.759,55,7419.69,56,500.124,57,227.601,58,8752.08,59,2612.41,60,272.726,61,433.24,62,1218.79,63,9140.6,64,487.088,65,528.057,66,6525.64,67,791.952,68,2029.59,69,9147.08,70,730.828,71,494.811,72,1575.45,73,1745.62,74,1424.55,75,507.949,76,2393.02,77,4394.15,78,1415.53,79,2287.33,80,3547.41,81,552.488,82,9805.32,83,410.58,84,9477.62,85,8020.95,86,277.74,87,1050.09,88,395.505,89,6095.86,90,799.67,91,996.54,92,991.368,93,6526.81,94,1030.35,95,1136.57,96,1653.13,97,684.465,98,1045.65,99,526.485,100,1278.19)
.param rcsRF=table(run,1,1239.08,2,252.172,3,353.315,4,768.836,5,756.477,6,442.355,7,240.044,8,693.918,9,1814.5,10,333.471,11,411.244,12,910.47,13,249.74,14,340.89,15,382.633,16,3448.35,17,1237.19,18,2833.83,19,1275.81,20,662.139,21,8608.85,22,312.838,23,594.366,24,2158.59,25,393.459,26,1177.39,27,575.215,28,9323.45,29,3834.5,30,259.985,31,253.94,32,365.591,33,1097.58,34,553.71,35,1428.51,36,211.277,37,738.763,38,623.425,39,289.296,40,4010.53,41,242.706,42,639.104,43,1719.13,44,5150.56,45,7153.28,46,812.522,47,3564.9,48,9598.94,49,2399.29,50,2286.03,51,800.719,52,6053.69,53,8072.96,54,8234.72,55,1629.54,56,298.54,57,640.669,58,1240.51,59,5741.3,60,687.401,61,4489.03,62,392.223,63,631.033,64,240.477,65,4275.88,66,299.247,67,6777.95,68,1757.13,69,594.215,70,1601.46,71,731.645,72,3657.45,73,2582.23,74,841.829,75,400.099,76,4522.84,77,232.967,78,2663.93,79,6178.34,80,727.86,81,3811.13,82,3798.84,83,432.595,84,1478.68,85,2495.21,86,4111.47,87,2409.3,88,9329.97,89,220.55,90,6742.18,91,558.034,92,1810.61,93,375.232,94,803.9,95,2756.27,96,553.209,97,398.919,98,964.652,99,498.984,100,227.439)
Ibp sa 0 {ibp}
Ibn sb 0 {ibn}

.end

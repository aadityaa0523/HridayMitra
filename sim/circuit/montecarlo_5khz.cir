* ===== HridayMitra: Monte Carlo, 100 devices x 4 paths x 2 fluid levels =====

.param f=5000 path=1 fx=1 calv=3.3
.param fl={fx} ft={fx}
V1 vcc 0 3.3
R1 vcc vrefin 10k
R2 vrefin 0 10k
C1 vrefin 0 10u
Bu1a vref 0 V=limit(V(vrefin),0.05,3.25)
Vdac dac 0 SIN(1.65 {amp} {f})
C2 dac excin {c2}
R3 excin vref {r3}
Bu1b excout 0 V=limit(V(excin),0.05,3.25)
C3 excout n1 {c3}
R4 n1 injP {r4}
C4 injN ret {c4}
R5 ret ncal {r5}
Rcal ncal vref {rcal}
* --- body: arms to shoulder node SH, trunk SH-PV, legs to pelvis node PV (Cole: Re || Ri+Cm) ---
ReLH LH SH {330*sz}
RiLH LH mLH {750*sz}
CmLH mLH SH {2.9e-09/sz}
ReRH RH SH {330*sz}
RiRH RH mRH {750*sz}
CmRH mRH SH {2.9e-09/sz}
ReLF LF PV {290/fl*sz}
RiLF LF mLF {650*sz}
CmLF mLF PV {3.39e-09/sz}
ReRF RF PV {290/fl*sz}
RiRF RF mRF {650*sz}
CmRF mRF PV {3.39e-09/sz}
ReT SH PV {28/ft*sz}
RiT SH mT {60*sz}
CmT mT PV {3e-08/sz}
* --- electrodes: every hand/foot has an inject (i) and a sense (s) plate, each with contact Rc ---
RciLH iLH LH {rciLH}
RcsLH sLH LH {rcsLH}
RciRH iRH RH {rciRH}
RcsRH sRH RH {rcsRH}
RciLF iLF LF {rciLF}
RcsLF sLF LF {rcsLF}
RciRF iRF RF {rciRF}
RcsRF sRF RF {rcsRF}
* --- path mux (74HC4052, Ron 100 ohm): picks inject pair and sense pair ---
.model SW SW(Ron=100 Roff=1G Vt=1.65 Vh=0.1)
Bm1 c1 0 V=if(abs(path-2)<0.5,3.3,0) + if(abs(path-3)<0.5,3.3,0)
Sm1 injP iLH c1 0 SW
Bm2 c2 0 V=if(abs(path-4)<0.5,3.3,0)
Sm2 injP iRH c2 0 SW
Bm3 c3 0 V=if(abs(path-1)<0.5,3.3,0)
Sm3 injP iLF c3 0 SW
Bm4 c4 0 V=if(abs(path-2)<0.5,3.3,0)
Sm4 injN iRH c4 0 SW
Bm5 c5 0 V=if(abs(path-3)<0.5,3.3,0)
Sm5 injN iLF c5 0 SW
Bm6 c6 0 V=if(abs(path-1)<0.5,3.3,0) + if(abs(path-4)<0.5,3.3,0)
Sm6 injN iRF c6 0 SW
Bm7 c7 0 V=if(abs(path-2)<0.5,3.3,0) + if(abs(path-3)<0.5,3.3,0)
Sm7 sraw_p sLH c7 0 SW
Bm8 c8 0 V=if(abs(path-4)<0.5,3.3,0)
Sm8 sraw_p sRH c8 0 SW
Bm9 c9 0 V=if(abs(path-1)<0.5,3.3,0)
Sm9 sraw_p sLF c9 0 SW
Bm10 c10 0 V=if(abs(path-2)<0.5,3.3,0)
Sm10 sraw_n sRH c10 0 SW
Bm11 c11 0 V=if(abs(path-3)<0.5,3.3,0)
Sm11 sraw_n sLF c11 0 SW
Bm12 c12 0 V=if(abs(path-1)<0.5,3.3,0) + if(abs(path-4)<0.5,3.3,0)
Sm12 sraw_n sRF c12 0 SW
* --- sense lines: 1k protection, 1M bias to VREF ---
R6 sraw_p sa {r6}
R7 sraw_n sb {r7}
R8 sa vref {r8}
R9 sb vref {r9}
* --- 74HC4053 selector: selv=0 body, selv=3.3 reference; switch C (calv): 3.3 = across Rcal, 0 = across R5+Rcal ---
Vsel sel 0 PULSE(0 3.3 0.02 1u 1u 0.02 0.1)
Bch chi 0 V=V(sel)
Bcl clo 0 V=3.3-V(sel)
Vcal calsel 0 {calv}
Bcc ccal 0 V=V(calsel)
Bcn cnot 0 V=3.3-V(calsel)
S5 rtap ncal ccal 0 SW
S6 rtap ret cnot 0 SW
S1 inp sa clo 0 SW
S2 inp rtap chi 0 SW
S3 inn sb clo 0 SW
S4 inn vref chi 0 SW
Bina ina 0 V=limit(V(vref)+{gain}*(V(inp)-V(inn))+{gain}*{cmrr}*((V(inp)+V(inn))/2-V(vref)),0.05,3.25)
R11 ina adc {r11}
C5 adc 0 {c5}
Radc adc 0 10Meg
* --- DC definition of floating nodes ---
Rd0 n1 vref 1G
Rd1 injP vref 1G
Rd2 injN vref 1G
Rd3 SH vref 1G
Rd4 PV vref 1G
Rd5 mT vref 1G
Rd6 sraw_p vref 1G
Rd7 sraw_n vref 1G
Rd8 ncal vref 1G
Rd9 rtap vref 1G
Rd10 LH vref 1G
Rd11 RH vref 1G
Rd12 LF vref 1G
Rd13 RF vref 1G
Rd14 mLH vref 1G
Rd15 mRH vref 1G
Rd16 mLF vref 1G
Rd17 mRF vref 1G
Rd18 iLH vref 1G
Rd19 iRH vref 1G
Rd20 iLF vref 1G
Rd21 iRF vref 1G
Rd22 sLH vref 1G
Rd23 sRH vref 1G
Rd24 sLF vref 1G
Rd25 sRF vref 1G
.tran 0 0.04 0 5u
.save V(adc) V(ina)
.meas TRAN amax MAX V(ina) FROM=0.008 TO=0.039
.meas TRAN amin MIN V(ina) FROM=0.008 TO=0.039
.step param fx list 1 1.1
.step param path list 1 2 3 4
.step param run 1 100 1
.meas TRAN vbody PP V(adc) FROM=0.008 TO=0.019
.meas TRAN vsens PP V(adc) FROM=0.028 TO=0.039
.meas TRAN zmeas PARAM 100*vbody/vsens
.save V(adc) I(R4)
.param r3=table(run,1,101251,2,101292,3,96502,4,96805.5,5,102652,6,100212,7,99792,8,100904,9,103826,10,103306,11,102109,12,102577,13,100750,14,96837,15,99650.6,16,99334.9,17,100932,18,99472.9,19,95732.9,20,99765.4,21,99413.3,22,102722,23,96842.7,24,97742.6,25,97195.1,26,99531.5,27,97700.5,28,96163.4,29,103871,30,102372,31,103023,32,97003,33,103977,34,95668.5,35,95458.9,36,97526.5,37,101231,38,99292.3,39,98183.2,40,99648.9,41,103698,42,102155,43,99081,44,101402,45,102637,46,101718,47,95170.2,48,104598,49,102454,50,95737.7,51,104924,52,103172,53,104504,54,104906,55,97481.1,56,100949,57,97366.9,58,99611.6,59,103549,60,101690,61,102346,62,96672.2,63,102314,64,99299.9,65,98254.8,66,98425.2,67,104652,68,99628.4,69,103225,70,104620,71,95351.8,72,102414,73,100988,74,98363.1,75,100098,76,96794.8,77,101511,78,102351,79,97597.4,80,99855.2,81,100733,82,101963,83,104824,84,95904.2,85,97212.4,86,96513.5,87,99486.7,88,99650.8,89,98671.6,90,102975,91,96947.4,92,97562.4,93,104431,94,104558,95,103173,96,96848.6,97,99922.8,98,100995,99,102050,100,103999)
.param r4=table(run,1,4886.69,2,4706.64,3,4848.68,4,4880.51,5,4892.31,6,4886.37,7,4744.5,8,4543.03,9,4557.72,10,4642.12,11,4510.5,12,4804.01,13,4674.75,14,4779.84,15,4879,16,4660.09,17,4569.43,18,4800.06,19,4872.28,20,4711.6,21,4765.72,22,4565.5,23,4607.84,24,4824.41,25,4592.42,26,4920.22,27,4639.97,28,4844.86,29,4896.49,30,4783.95,31,4573.15,32,4931,33,4763.88,34,4525.67,35,4930.5,36,4473.62,37,4510.87,38,4561.64,39,4516.07,40,4598.8,41,4771.68,42,4557.58,43,4753.35,44,4895.22,45,4493.04,46,4809.58,47,4829.1,48,4530.15,49,4636.16,50,4773.74,51,4752.44,52,4909.28,53,4505.38,54,4803.82,55,4916.07,56,4628.95,57,4494.62,58,4588.99,59,4760.64,60,4803.93,61,4804.32,62,4775.98,63,4859.19,64,4677.27,65,4560.55,66,4930.04,67,4625.49,68,4857.26,69,4791.2,70,4699.42,71,4601.83,72,4533.25,73,4703.19,74,4508.58,75,4563.72,76,4825.18,77,4600.79,78,4620.2,79,4819.1,80,4635.47,81,4596.49,82,4691.64,83,4514.56,84,4816.74,85,4699.22,86,4754.9,87,4529.01,88,4682.1,89,4876.03,90,4843.73,91,4750.29,92,4641.86,93,4760.27,94,4572.52,95,4869.45,96,4493.32,97,4569.6,98,4536.3,99,4500.74,100,4723.69)
.param r5=table(run,1,123.308,2,119.962,3,118.553,4,121.699,5,115.813,6,122.913,7,121.911,8,122.134,9,120.884,10,118.461,11,122.728,12,119.338,13,123.005,14,117.19,15,123.132,16,122.305,17,116.347,18,114.413,19,117.756,20,121.572,21,115.629,22,125.44,23,119.37,24,121.297,25,116.076,26,117.839,27,120.5,28,117.731,29,117.726,30,125.967,31,116.805,32,117.439,33,115.118,34,122.317,35,120.95,36,120.481,37,122.033,38,121.975,39,123.731,40,125.032,41,117.527,42,117.19,43,124.637,44,123.611,45,122.431,46,114.512,47,116.114,48,125.585,49,115.053,50,124.722,51,124.46,52,124.077,53,123.093,54,115.756,55,122.938,56,118.261,57,116.289,58,119.772,59,120.707,60,115.886,61,114.821,62,123.384,63,117.059,64,118.989,65,114.164,66,116.62,67,120.944,68,118.288,69,124.922,70,116.944,71,119.862,72,117.117,73,123.448,74,116.411,75,116.506,76,120.003,77,121.475,78,119.96,79,118.499,80,115.158,81,116.907,82,118.231,83,120.364,84,118.089,85,117.942,86,114.793,87,117.229,88,117.342,89,118.577,90,116.606,91,118.767,92,124.13,93,124.954,94,121.465,95,123.288,96,124.746,97,114.029,98,118.869,99,115.334,100,122.52)
.param rcal=table(run,1,99.9286,2,99.9344,3,100.124,4,100.018,5,100.113,6,100.021,7,99.9497,8,99.8755,9,100.036,10,100.01,11,100.072,12,99.9683,13,99.9195,14,100.007,15,100.086,16,100.087,17,100.098,18,99.9713,19,99.9986,20,99.9228,21,99.9059,22,100.1,23,100.111,24,99.9513,25,99.8864,26,99.8808,27,100.049,28,100.073,29,100.061,30,99.9107,31,99.9423,32,100.027,33,99.9527,34,100.081,35,99.8842,36,99.9692,37,100.12,38,99.9453,39,100.079,40,99.9522,41,100.072,42,99.9544,43,100.054,44,99.9119,45,100.108,46,99.8939,47,99.9896,48,100.043,49,100.011,50,99.9622,51,100.126,52,100.038,53,100.095,54,100.014,55,100.092,56,100.035,57,99.922,58,99.9572,59,99.9279,60,100.052,61,100.116,62,100.068,63,99.8941,64,99.9321,65,99.9998,66,99.9891,67,100.116,68,100.079,69,99.9402,70,100.068,71,100.091,72,100.078,73,99.9512,74,100.074,75,99.9746,76,100.042,77,100.098,78,99.9921,79,99.9944,80,99.8929,81,99.8956,82,99.9344,83,99.8987,84,100.08,85,99.9314,86,99.8735,87,100.125,88,99.875,89,99.9865,90,100.087,91,100.08,92,100.116,93,99.8854,94,99.9388,95,100.013,96,99.9769,97,99.9266,98,99.9393,99,100.041,100,100.089)
.param r6=table(run,1,980.017,2,951.179,3,1009,4,987.629,5,950.518,6,992.665,7,1046.14,8,981.057,9,1010.93,10,971.506,11,1032.58,12,991.977,13,1041.44,14,978.295,15,1026.11,16,983.508,17,969.784,18,1036.03,19,969.802,20,1046.21,21,967.372,22,961.436,23,977.842,24,1012.89,25,996.579,26,989.22,27,1005.92,28,951.272,29,975.312,30,1031.29,31,980.392,32,1049.06,33,952.793,34,1028.66,35,1001.13,36,1000.37,37,1048.08,38,989.915,39,1006.21,40,1019.53,41,978.928,42,1009.13,43,997.089,44,997.734,45,1046.77,46,999.984,47,1002.26,48,1029.59,49,1012.28,50,960.507,51,1024.05,52,968.705,53,1000.89,54,965.937,55,1019.88,56,1036.42,57,991.486,58,1026.71,59,1037.51,60,975.446,61,1007.69,62,1017.53,63,1008.61,64,1045.18,65,957.605,66,1047.21,67,979.759,68,1028.2,69,1028.52,70,1031.56,71,977.003,72,1041.22,73,1033.1,74,1013.45,75,1028.98,76,1023.4,77,960.705,78,1016.16,79,1042.76,80,1012.95,81,982.471,82,979.686,83,968.979,84,959.556,85,1043.52,86,1021.55,87,1029.11,88,1026.65,89,1006.65,90,1006.84,91,1016.63,92,968.12,93,1039.16,94,1031.68,95,1039.93,96,1000.83,97,982.15,98,951.657,99,1017.28,100,959.046)
.param r7=table(run,1,1037.36,2,969.24,3,1010.51,4,991.096,5,1025.3,6,1037.82,7,996.584,8,1043.83,9,959.625,10,974.741,11,1017.42,12,953.334,13,971.719,14,1001.62,15,1020.77,16,1016.97,17,995.429,18,1007.95,19,992.024,20,978.914,21,978.333,22,981.52,23,1039.86,24,995.471,25,971.44,26,965.337,27,960.703,28,1037.13,29,963.952,30,991.109,31,1026.07,32,1045.01,33,971.919,34,995.24,35,1000.41,36,979.584,37,1038.92,38,996.341,39,963.774,40,990.935,41,1039.48,42,1012.79,43,1031.46,44,999.193,45,1021.6,46,955.026,47,1011.44,48,1013.51,49,1042.18,50,1012.03,51,1014.47,52,1032.3,53,1029.76,54,953.92,55,981.565,56,984.083,57,982.17,58,1033.17,59,1026.07,60,975.784,61,977.232,62,951.749,63,999.902,64,956.866,65,1039.99,66,950.671,67,1030.89,68,996.867,69,1037.31,70,1013.06,71,1032.31,72,1037.01,73,951.855,74,1029.72,75,953.9,76,1010.66,77,997.997,78,971.621,79,1021.84,80,1027.35,81,1027.41,82,954.982,83,1026.42,84,999.398,85,1000.75,86,984.271,87,956.988,88,1019.6,89,972.13,90,1016.87,91,1022.17,92,951.058,93,1037.73,94,970.077,95,999.196,96,1043.63,97,993.93,98,1046.57,99,1021.04,100,997.422)
.param r8=table(run,1,9.50527e+06,2,1.0192e+07,3,1.0138e+07,4,9.73949e+06,5,1.03105e+07,6,9.91165e+06,7,1.01281e+07,8,1.00384e+07,9,1.01612e+07,10,9.82985e+06,11,9.87073e+06,12,1.03443e+07,13,1.02691e+07,14,1.01285e+07,15,1.03497e+07,16,9.70904e+06,17,1.02503e+07,18,1.00578e+07,19,1.0328e+07,20,9.80602e+06,21,1.04617e+07,22,9.53244e+06,23,1.01805e+07,24,1.03624e+07,25,1.02388e+07,26,9.58189e+06,27,1.03179e+07,28,9.66231e+06,29,9.93788e+06,30,1.02833e+07,31,9.87418e+06,32,9.54235e+06,33,9.52543e+06,34,9.67706e+06,35,9.93539e+06,36,1.01568e+07,37,1.03066e+07,38,1.04044e+07,39,1.00419e+07,40,1.04354e+07,41,9.58276e+06,42,1.04314e+07,43,9.98531e+06,44,1.04895e+07,45,1.0363e+07,46,1.00043e+07,47,1.04895e+07,48,1.03703e+07,49,1.03878e+07,50,9.62704e+06,51,9.72124e+06,52,1.02281e+07,53,9.94105e+06,54,1.04438e+07,55,9.89111e+06,56,9.6907e+06,57,9.86255e+06,58,9.64117e+06,59,1.00129e+07,60,9.62013e+06,61,9.93414e+06,62,9.7296e+06,63,9.97932e+06,64,9.70495e+06,65,1.01876e+07,66,9.79506e+06,67,9.61408e+06,68,1.03966e+07,69,9.85505e+06,70,1.04162e+07,71,9.74454e+06,72,1.00019e+07,73,9.73826e+06,74,9.54449e+06,75,1.03373e+07,76,9.69776e+06,77,9.52265e+06,78,9.52507e+06,79,1.02363e+07,80,1.04075e+07,81,9.5216e+06,82,9.75507e+06,83,9.5661e+06,84,9.59976e+06,85,1.01505e+07,86,1.01973e+07,87,1.02068e+07,88,1.03406e+07,89,9.76745e+06,90,1.03516e+07,91,9.75115e+06,92,1.04615e+07,93,1.01289e+07,94,9.92078e+06,95,9.60596e+06,96,9.71943e+06,97,9.94717e+06,98,9.95922e+06,99,1.02201e+07,100,1.01056e+07)
.param r9=table(run,1,1.03212e+07,2,9.70061e+06,3,1.01765e+07,4,9.53806e+06,5,9.63676e+06,6,1.04228e+07,7,1.01352e+07,8,1.03116e+07,9,1.0132e+07,10,9.95743e+06,11,9.56421e+06,12,1.00424e+07,13,9.5676e+06,14,1.00362e+07,15,1.01815e+07,16,1.00517e+07,17,1.02073e+07,18,1.01647e+07,19,1.03276e+07,20,9.75631e+06,21,9.52579e+06,22,1.03309e+07,23,1.03535e+07,24,9.79294e+06,25,1.04225e+07,26,1.00679e+07,27,1.04239e+07,28,9.95575e+06,29,1.01025e+07,30,1.03918e+07,31,9.82319e+06,32,1.00212e+07,33,9.62616e+06,34,9.5353e+06,35,1.04513e+07,36,9.67309e+06,37,9.67795e+06,38,9.74636e+06,39,1.01295e+07,40,1.0448e+07,41,9.61899e+06,42,9.51272e+06,43,1.04635e+07,44,9.5869e+06,45,1.03417e+07,46,1.02363e+07,47,1.01874e+07,48,9.82624e+06,49,9.55715e+06,50,1.03916e+07,51,9.87042e+06,52,1.02469e+07,53,9.85335e+06,54,9.83785e+06,55,9.94068e+06,56,9.50279e+06,57,1.03169e+07,58,9.66443e+06,59,9.66102e+06,60,9.89691e+06,61,1.00176e+07,62,1.00146e+07,63,1.02813e+07,64,1.0162e+07,65,9.87e+06,66,1.03212e+07,67,1.02333e+07,68,9.88452e+06,69,9.91019e+06,70,9.58891e+06,71,9.80315e+06,72,9.8674e+06,73,9.67725e+06,74,1.04008e+07,75,1.04903e+07,76,1.01985e+07,77,1.0345e+07,78,9.58856e+06,79,9.83934e+06,80,9.86499e+06,81,9.98266e+06,82,1.04531e+07,83,9.88271e+06,84,1.02804e+07,85,1.02044e+07,86,1.02799e+07,87,9.87603e+06,88,9.6533e+06,89,9.76665e+06,90,9.90547e+06,91,9.56385e+06,92,1.03596e+07,93,9.92947e+06,94,9.7197e+06,95,9.77212e+06,96,1.04682e+07,97,1.00483e+07,98,9.63472e+06,99,1.01629e+07,100,9.55778e+06)
.param r11=table(run,1,1544.56,2,1480.43,3,1447.62,4,1556.43,5,1487.84,6,1435.31,7,1452.58,8,1523.7,9,1548.58,10,1437.23,11,1502.82,12,1483.13,13,1496.01,14,1484.34,15,1535.35,16,1540.38,17,1508.02,18,1526.65,19,1496.05,20,1435.12,21,1452.56,22,1562.26,23,1485.49,24,1538.66,25,1465.95,26,1568.04,27,1440.19,28,1524.26,29,1565.34,30,1573.8,31,1520.45,32,1515.2,33,1519.98,34,1552.71,35,1567.32,36,1561,37,1570.52,38,1532.8,39,1489.24,40,1429.51,41,1537.5,42,1454.02,43,1467.37,44,1501.62,45,1478.75,46,1523.61,47,1483.86,48,1531.21,49,1540.78,50,1443.37,51,1518.53,52,1529.62,53,1500.86,54,1453.44,55,1469.01,56,1445.62,57,1428.2,58,1482.55,59,1457.38,60,1427.98,61,1502.67,62,1530.43,63,1494.47,64,1513.43,65,1551.23,66,1439.36,67,1546,68,1537.49,69,1475.1,70,1504.14,71,1508.07,72,1491.79,73,1463.6,74,1482.34,75,1508.87,76,1442.39,77,1541.77,78,1451.89,79,1551.05,80,1565.64,81,1515.42,82,1426.21,83,1453.75,84,1509,85,1548.17,86,1550.3,87,1532.99,88,1460.56,89,1464.01,90,1562.95,91,1556.99,92,1516.14,93,1530.74,94,1554.08,95,1523.63,96,1484.48,97,1496.12,98,1557.74,99,1507.89,100,1543.38)
.param c2=table(run,1,9.87174e-07,2,8.01494e-07,3,9.76125e-07,4,9.87092e-07,5,1.1261e-06,6,9.71999e-07,7,8.24746e-07,8,1.0443e-06,9,1.12141e-06,10,1.10109e-06,11,1.10298e-06,12,1.01921e-06,13,8.13023e-07,14,1.11633e-06,15,9.20658e-07,16,8.26126e-07,17,1.12282e-06,18,1.03344e-06,19,1.10716e-06,20,9.69169e-07,21,8.66019e-07,22,1.19592e-06,23,8.01311e-07,24,1.05427e-06,25,1.0289e-06,26,1.03176e-06,27,8.99808e-07,28,1.00315e-06,29,8.58361e-07,30,9.06417e-07,31,8.74628e-07,32,1.08096e-06,33,8.40177e-07,34,1.19108e-06,35,8.49987e-07,36,1.18403e-06,37,8.81089e-07,38,9.23747e-07,39,1.14555e-06,40,1.19781e-06,41,9.79671e-07,42,9.44801e-07,43,8.50957e-07,44,1.16575e-06,45,8.39618e-07,46,1.04666e-06,47,1.08601e-06,48,9.05645e-07,49,9.04545e-07,50,9.44748e-07,51,1.17056e-06,52,1.13201e-06,53,8.77897e-07,54,8.40717e-07,55,9.68577e-07,56,1.14048e-06,57,8.41358e-07,58,9.85315e-07,59,9.51717e-07,60,1.06279e-06,61,8.99183e-07,62,9.54569e-07,63,9.98813e-07,64,9.11459e-07,65,1.11874e-06,66,1.17132e-06,67,1.13498e-06,68,1.0559e-06,69,8.02291e-07,70,1.09716e-06,71,1.06156e-06,72,8.70555e-07,73,1.17821e-06,74,1.17047e-06,75,9.44005e-07,76,9.07925e-07,77,8.18413e-07,78,1.1429e-06,79,9.54303e-07,80,9.1875e-07,81,8.19848e-07,82,1.09099e-06,83,1.14011e-06,84,8.93875e-07,85,9.05288e-07,86,1.04633e-06,87,9.18178e-07,88,1.03845e-06,89,1.00621e-06,90,1.1525e-06,91,1.17426e-06,92,1.12677e-06,93,8.97567e-07,94,1.04777e-06,95,9.51651e-07,96,8.98967e-07,97,8.13146e-07,98,1.19405e-06,99,1.09654e-06,100,1.08622e-06)
.param c3=table(run,1,9.21213e-07,2,1.13202e-06,3,8.95826e-07,4,1.01905e-06,5,8.05708e-07,6,1.00781e-06,7,9.64607e-07,8,8.76501e-07,9,9.30867e-07,10,1.03162e-06,11,8.76335e-07,12,1.08866e-06,13,9.25524e-07,14,1.14937e-06,15,8.67056e-07,16,1.09114e-06,17,9.86326e-07,18,9.68252e-07,19,9.83227e-07,20,1.10873e-06,21,9.89739e-07,22,1.04477e-06,23,1.11479e-06,24,1.09617e-06,25,1.00269e-06,26,1.05885e-06,27,8.69472e-07,28,8.66159e-07,29,1.08495e-06,30,9.81175e-07,31,8.42568e-07,32,9.34364e-07,33,8.62305e-07,34,8.97654e-07,35,8.60688e-07,36,9.97197e-07,37,1.14762e-06,38,1.15777e-06,39,9.56018e-07,40,1.04197e-06,41,8.58985e-07,42,1.1272e-06,43,1.13216e-06,44,9.5954e-07,45,1.09099e-06,46,8.18562e-07,47,9.86693e-07,48,1.00346e-06,49,1.07888e-06,50,9.97864e-07,51,9.20739e-07,52,9.19137e-07,53,9.22995e-07,54,1.06086e-06,55,1.10847e-06,56,1.04983e-06,57,1.12312e-06,58,1.18253e-06,59,9.3245e-07,60,1.09924e-06,61,9.05986e-07,62,9.79707e-07,63,9.94906e-07,64,1.17478e-06,65,9.30576e-07,66,1.13382e-06,67,1.19002e-06,68,9.325e-07,69,8.92623e-07,70,1.16673e-06,71,1.15203e-06,72,9.98396e-07,73,8.09558e-07,74,1.03781e-06,75,8.93574e-07,76,9.79255e-07,77,1.09832e-06,78,1.08673e-06,79,1.19532e-06,80,1.17595e-06,81,9.17589e-07,82,1.11557e-06,83,8.3295e-07,84,1.18514e-06,85,8.31438e-07,86,1.13869e-06,87,8.52066e-07,88,1.17465e-06,89,8.40201e-07,90,1.1231e-06,91,1.0574e-06,92,1.0377e-06,93,1.06706e-06,94,1.05233e-06,95,9.69128e-07,96,8.93482e-07,97,9.06787e-07,98,1.1264e-06,99,8.32611e-07,100,1.17449e-06)
.param c4=table(run,1,9.1137e-07,2,8.61784e-07,3,9.60999e-07,4,9.28865e-07,5,1.05138e-06,6,1.18038e-06,7,1.10561e-06,8,1.02976e-06,9,1.08882e-06,10,9.19878e-07,11,9.06495e-07,12,9.52584e-07,13,9.24892e-07,14,8.71749e-07,15,1.10261e-06,16,8.06173e-07,17,1.04815e-06,18,8.73393e-07,19,9.49343e-07,20,1.08383e-06,21,8.06029e-07,22,1.06639e-06,23,8.9819e-07,24,9.51305e-07,25,8.30043e-07,26,9.29452e-07,27,1.13966e-06,28,8.55647e-07,29,9.90186e-07,30,1.17711e-06,31,1.07885e-06,32,9.31163e-07,33,1.16112e-06,34,1.14643e-06,35,9.62995e-07,36,9.86156e-07,37,1.15115e-06,38,9.57632e-07,39,1.00435e-06,40,8.29541e-07,41,1.00537e-06,42,1.01996e-06,43,9.1892e-07,44,9.04687e-07,45,8.54765e-07,46,8.94662e-07,47,9.65248e-07,48,1.0726e-06,49,9.51793e-07,50,8.47149e-07,51,9.58084e-07,52,1.06898e-06,53,9.2215e-07,54,9.8446e-07,55,8.30281e-07,56,1.19625e-06,57,1.01359e-06,58,1.17668e-06,59,8.24422e-07,60,1.11022e-06,61,9.45435e-07,62,1.13629e-06,63,9.81835e-07,64,9.63782e-07,65,1.13889e-06,66,8.57221e-07,67,1.08438e-06,68,1.01271e-06,69,9.32615e-07,70,1.05658e-06,71,1.15179e-06,72,8.92355e-07,73,9.19498e-07,74,1.01893e-06,75,8.7318e-07,76,8.45776e-07,77,1.07662e-06,78,1.09999e-06,79,1.15836e-06,80,1.16753e-06,81,1.16259e-06,82,9.61884e-07,83,9.34631e-07,84,1.0728e-06,85,9.86898e-07,86,1.06355e-06,87,8.0788e-07,88,9.8871e-07,89,1.11215e-06,90,9.51977e-07,91,1.1687e-06,92,1.16192e-06,93,1.0777e-06,94,9.25799e-07,95,9.60884e-07,96,1.00738e-06,97,1.18481e-06,98,9.01458e-07,99,8.84724e-07,100,9.48815e-07)
.param c5=table(run,1,9.50974e-09,2,9.5352e-09,3,9.19341e-09,4,1.05026e-08,5,1.0586e-08,6,9.502e-09,7,1.06304e-08,8,9.07937e-09,9,1.07345e-08,10,9.15509e-09,11,1.00722e-08,12,1.06613e-08,13,1.04395e-08,14,9.27262e-09,15,9.33167e-09,16,1.09167e-08,17,1.06378e-08,18,9.58528e-09,19,1.00918e-08,20,9.39114e-09,21,9.91635e-09,22,1.03568e-08,23,9.28496e-09,24,1.04498e-08,25,9.24975e-09,26,1.01422e-08,27,1.08206e-08,28,9.56907e-09,29,9.26342e-09,30,1.08915e-08,31,1.05129e-08,32,9.00857e-09,33,9.6709e-09,34,9.80506e-09,35,1.06681e-08,36,1.07192e-08,37,1.02438e-08,38,1.00103e-08,39,9.22829e-09,40,9.99406e-09,41,9.59394e-09,42,1.0024e-08,43,1.06948e-08,44,1.01119e-08,45,9.7684e-09,46,1.0795e-08,47,9.73131e-09,48,9.40225e-09,49,9.64416e-09,50,9.6375e-09,51,9.04447e-09,52,1.00346e-08,53,1.09768e-08,54,9.02335e-09,55,9.55315e-09,56,9.13892e-09,57,9.87778e-09,58,1.09341e-08,59,9.81275e-09,60,9.25772e-09,61,1.05618e-08,62,9.04709e-09,63,9.81146e-09,64,1.01925e-08,65,1.08588e-08,66,1.01847e-08,67,1.09544e-08,68,1.02121e-08,69,9.21681e-09,70,1.02046e-08,71,9.50032e-09,72,9.3239e-09,73,1.01488e-08,74,1.06362e-08,75,9.64667e-09,76,9.21198e-09,77,9.2525e-09,78,9.88846e-09,79,1.03182e-08,80,9.31e-09,81,1.09887e-08,82,1.01905e-08,83,1.07125e-08,84,9.67268e-09,85,9.34001e-09,86,1.08546e-08,87,9.59137e-09,88,9.40165e-09,89,9.3496e-09,90,1.00564e-08,91,1.04126e-08,92,9.48669e-09,93,1.00798e-08,94,9.35298e-09,95,9.38407e-09,96,9.93393e-09,97,9.05483e-09,98,9.38109e-09,99,1.04829e-08,100,9.93831e-09)
.param gain=table(run,1,9.99451,2,10.038,3,10.0468,4,9.95252,5,10.0013,6,10.0306,7,10.023,8,10.0302,9,10.0393,10,10.0263,11,10.0248,12,10.0419,13,9.9955,14,9.96132,15,10.0419,16,9.99687,17,10.0178,18,9.97929,19,9.97013,20,9.96369,21,9.96629,22,10.007,23,10.0299,24,10.0198,25,10.0385,26,10.0252,27,9.95443,28,9.95524,29,10.0473,30,9.98729,31,9.97964,32,9.95352,33,9.9833,34,9.98113,35,10.0124,36,9.97898,37,10.0021,38,10.0377,39,10.0064,40,9.95495,41,10.0049,42,10.026,43,10.0109,44,9.98201,45,10.0496,46,9.96232,47,9.99934,48,9.95612,49,9.99883,50,9.97753,51,10.0197,52,9.98378,53,9.98352,54,10.0215,55,9.9979,56,9.9866,57,9.97673,58,10.023,59,9.99487,60,10.0141,61,9.99374,62,9.97686,63,9.96609,64,9.9591,65,10.012,66,10.0055,67,9.97784,68,10.0037,69,10.0266,70,9.98882,71,10.0246,72,9.98806,73,10.0203,74,10.0125,75,10.0352,76,10.0152,77,10.0025,78,9.96028,79,10.0331,80,10.0361,81,10.035,82,9.97209,83,10.0187,84,10.0355,85,9.95204,86,10.0397,87,10.036,88,10.0095,89,9.9944,90,9.96731,91,10.0106,92,9.99441,93,9.97601,94,10.0357,95,9.95935,96,10.0386,97,10.0234,98,10.0025,99,9.96926,100,10.0412)
.param amp=table(run,1,0.830604,2,0.8313,3,0.792153,4,0.813026,5,0.859993,6,0.853435,7,0.778634,8,0.891097,9,0.785049,10,0.781007,11,0.882667,12,0.815051,13,0.77114,14,0.89369,15,0.842834,16,0.817925,17,0.848835,18,0.820803,19,0.805639,20,0.806286,21,0.799408,22,0.890082,23,0.854744,24,0.815059,25,0.826567,26,0.841857,27,0.807745,28,0.792357,29,0.855998,30,0.88846,31,0.848066,32,0.836648,33,0.775092,34,0.830684,35,0.860521,36,0.870252,37,0.790216,38,0.852943,39,0.865384,40,0.836493,41,0.862365,42,0.850592,43,0.83119,44,0.886716,45,0.83794,46,0.834412,47,0.800941,48,0.868638,49,0.834055,50,0.858326,51,0.822506,52,0.807004,53,0.793994,54,0.797687,55,0.853403,56,0.86927,57,0.83562,58,0.853536,59,0.801724,60,0.874925,61,0.76873,62,0.802103,63,0.802817,64,0.88191,65,0.810317,66,0.855722,67,0.832863,68,0.778303,69,0.820299,70,0.83951,71,0.847927,72,0.772091,73,0.866359,74,0.853183,75,0.764032,76,0.862132,77,0.855147,78,0.825388,79,0.835849,80,0.85705,81,0.786136,82,0.852316,83,0.857002,84,0.814062,85,0.885734,86,0.769348,87,0.881955,88,0.890757,89,0.848834,90,0.864445,91,0.81925,92,0.852653,93,0.76388,94,0.865139,95,0.770118,96,0.770347,97,0.826862,98,0.841088,99,0.834084,100,0.818246)
.param cmrr=table(run,1,0.000101041,2,0.000142184,3,-0.000500703,4,0.000932502,5,-0.00063311,6,-0.000191829,7,0.000157748,8,0.000139956,9,-0.000223456,10,-0.000735857,11,0.000654229,12,-0.000728088,13,0.000129211,14,0.000114395,15,0.000115706,16,-0.000190351,17,-0.000276488,18,-0.000100217,19,0.000169623,20,0.000170508,21,0.000654535,22,0.000246683,23,0.00054003,24,-0.000940909,25,0.000857866,26,0.000157479,27,0.000339209,28,-0.000741131,29,-0.000124235,30,-0.000392743,31,0.000394168,32,-0.000839678,33,0.00021068,34,0.000981368,35,0.000616514,36,0.000516051,37,-0.00051213,38,0.000804713,39,0.000553375,40,0.000652447,41,-0.000872971,42,0.000513032,43,0.000163563,44,-0.000822624,45,-0.000112751,46,0.000891152,47,-0.00071045,48,-0.000155258,49,0.000230206,50,0.000103211,51,0.000583909,52,0.000699088,53,0.000726805,54,0.000165746,55,0.000188371,56,0.000218169,57,0.00013856,58,-0.000536548,59,-0.000465181,60,-0.000920514,61,-0.000628981,62,-0.000101676,63,0.000564702,64,-0.000788854,65,-0.00011406,66,0.000493355,67,-0.000825033,68,-0.000101988,69,0.00051927,70,0.000278742,71,-0.000167478,72,-0.000338568,73,-0.000602318,74,-0.000695662,75,-0.000215064,76,0.000425901,77,-0.000313402,78,-0.000137092,79,-0.000750284,80,0.000198409,81,-0.000354107,82,0.000195963,83,0.0009475,84,0.000114166,85,0.000385155,86,0.000539949,87,0.000178696,88,0.000135495,89,0.00038977,90,-0.000128548,91,0.000323841,92,-0.000608652,93,-0.000146631,94,-0.000184312,95,-0.000474122,96,0.0009037,97,0.000465049,98,0.000132312,99,0.000370446,100,-0.000146436)
.param sz=table(run,1,1.25486,2,1.1478,3,1.31185,4,0.786024,5,0.954189,6,1.14074,7,1.31438,8,0.735497,9,0.850273,10,0.791479,11,1.25968,12,1.23226,13,1.34143,14,0.861467,15,0.808591,16,1.06631,17,0.977258,18,0.946786,19,0.739696,20,1.04165,21,1.13199,22,0.935008,23,1.35745,24,1.37404,25,1.11637,26,1.08533,27,1.34511,28,1.02536,29,0.772166,30,0.962336,31,1.10457,32,0.841737,33,1.08299,34,1.0099,35,1.27244,36,1.20398,37,0.788116,38,0.795785,39,1.39431,40,0.957558,41,1.11465,42,0.760981,43,0.746147,44,0.844696,45,0.898828,46,1.35744,47,1.00816,48,1.16597,49,1.17478,50,0.953986,51,1.16175,52,1.04407,53,1.37606,54,1.04202,55,0.773683,56,0.74667,57,1.27683,58,0.960858,59,0.963785,60,0.835358,61,0.708689,62,0.859275,63,1.24798,64,0.975833,65,0.943099,66,0.968908,67,1.00726,68,1.37662,69,0.952244,70,1.33352,71,1.32826,72,1.1873,73,1.29665,74,1.12312,75,0.713311,76,0.972898,77,1.38315,78,1.05641,79,1.39201,80,1.28829,81,0.819451,82,1.2142,83,1.16537,84,0.907981,85,0.795512,86,0.972178,87,0.83624,88,1.32927,89,1.09421,90,0.812591,91,0.855707,92,1.20037,93,0.848592,94,1.398,95,1.0198,96,0.806949,97,0.959097,98,1.37707,99,1.28392,100,0.994986)
.param ibp=table(run,1,1.74436e-08,2,1.98354e-08,3,1.82443e-08,4,2.4343e-08,5,8.58812e-09,6,2.44312e-08,7,1.54661e-08,8,1.17732e-08,9,1.62742e-08,10,6.62525e-09,11,1.78904e-08,12,2.4859e-08,13,9.93151e-09,14,2.43982e-08,15,1.52893e-08,16,1.9617e-08,17,1.98858e-08,18,1.39476e-08,19,1.96565e-08,20,2.34637e-08,21,1.31262e-08,22,1.52575e-08,23,1.03708e-08,24,1.9272e-08,25,2.23062e-08,26,8.96288e-09,27,6.40346e-09,28,1.21302e-08,29,6.85318e-09,30,2.01324e-08,31,1.00684e-08,32,1.16654e-08,33,1.73583e-08,34,8.9911e-09,35,5.28042e-09,36,1.16802e-08,37,7.56382e-09,38,2.48146e-08,39,1.93987e-08,40,1.1094e-08,41,2.46733e-08,42,1.42461e-08,43,2.4303e-08,44,6.67742e-09,45,2.49886e-08,46,8.43127e-09,47,1.08652e-08,48,1.14286e-08,49,1.26815e-08,50,2.08144e-08,51,1.84619e-08,52,1.23743e-08,53,2.20662e-08,54,1.57116e-08,55,8.61506e-09,56,1.30288e-08,57,1.1437e-08,58,5.05367e-09,59,1.73806e-08,60,1.03555e-08,61,2.45406e-08,62,5.94226e-09,63,7.28076e-09,64,2.27115e-08,65,6.72584e-09,66,9.81602e-09,67,1.93936e-08,68,5.74949e-09,69,2.00677e-08,70,2.1542e-08,71,1.45839e-08,72,1.80281e-08,73,7.44184e-09,74,1.213e-08,75,6.39096e-09,76,9.15202e-09,77,1.77136e-08,78,1.76367e-08,79,2.10042e-08,80,1.57333e-08,81,1.46177e-08,82,1.48345e-08,83,1.98992e-08,84,2.46872e-08,85,2.0225e-08,86,1.0044e-08,87,1.20852e-08,88,1.32104e-08,89,1.60062e-08,90,1.98949e-08,91,1.35536e-08,92,1.02475e-08,93,6.48662e-09,94,1.61907e-08,95,2.37039e-08,96,1.71133e-08,97,1.53356e-08,98,2.32077e-08,99,1.82128e-08,100,1.17552e-08)
.param ibn=table(run,1,2.47792e-08,2,6.82991e-09,3,7.63232e-09,4,1.81552e-08,5,1.19212e-08,6,1.16536e-08,7,2.33127e-08,8,1.13601e-08,9,2.38961e-08,10,2.31278e-08,11,1.94195e-08,12,7.95976e-09,13,1.28822e-08,14,9.15635e-09,15,6.83108e-09,16,6.69516e-09,17,1.26086e-08,18,1.24326e-08,19,2.13486e-08,20,1.81277e-08,21,1.33519e-08,22,5.37326e-09,23,1.90481e-08,24,9.09477e-09,25,2.23413e-08,26,1.66545e-08,27,8.42558e-09,28,1.67366e-08,29,1.1631e-08,30,1.44242e-08,31,1.19643e-08,32,6.40943e-09,33,7.00761e-09,34,1.92491e-08,35,1.89697e-08,36,1.7052e-08,37,2.10234e-08,38,5.58211e-09,39,1.3475e-08,40,1.70442e-08,41,1.41959e-08,42,2.26033e-08,43,2.25395e-08,44,1.92378e-08,45,2.32396e-08,46,1.32004e-08,47,2.17388e-08,48,1.81635e-08,49,1.85468e-08,50,7.80682e-09,51,1.42865e-08,52,1.34303e-08,53,1.79412e-08,54,1.4144e-08,55,1.11796e-08,56,1.77527e-08,57,5.48999e-09,58,2.16591e-08,59,1.49466e-08,60,1.42397e-08,61,1.08744e-08,62,1.33293e-08,63,9.10841e-09,64,2.38999e-08,65,2.23562e-08,66,1.0838e-08,67,2.05689e-08,68,2.38856e-08,69,1.43964e-08,70,1.97439e-08,71,2.33221e-08,72,2.45052e-08,73,6.30044e-09,74,6.51175e-09,75,1.97012e-08,76,1.54326e-08,77,1.50399e-08,78,1.24839e-08,79,7.84885e-09,80,1.51354e-08,81,2.34576e-08,82,2.44083e-08,83,1.99635e-08,84,6.24966e-09,85,1.56601e-08,86,8.53783e-09,87,2.29847e-08,88,1.02459e-08,89,2.28505e-08,90,1.88834e-08,91,1.51528e-08,92,1.92004e-08,93,9.93269e-09,94,8.57114e-09,95,1.75333e-08,96,2.06269e-08,97,2.31932e-08,98,1.18416e-08,99,1.39038e-08,100,1.05451e-08)
.param rciLH=table(run,1,464.337,2,1661.18,3,5454.89,4,1067.98,5,8163.27,6,949.923,7,240.044,8,310.837,9,882.029,10,573.414,11,9874.48,12,3249.71,13,486.408,14,1450.5,15,8735,16,1807.99,17,1241.1,18,1944.73,19,1141.3,20,2269.51,21,4884.56,22,3398.59,23,331.999,24,3488.59,25,204.528,26,1364.95,27,1344.24,28,600.115,29,7845.03,30,1154.8,31,2170.88,32,225.663,33,553.71,34,1428.51,35,427.767,36,7482.6,37,7381.86,38,648.937,39,1013.79,40,4991.12,41,4059.76,42,2076.13,43,654.281,44,629.607,45,830.409,46,1698.22,47,5515.4,48,277.677,49,772.383,50,1933.24,51,418.278,52,5597.42,53,1066.26,54,2815.16,55,602.017,56,2947.84,57,6443.93,58,588.966,59,433.24,60,392.223,61,1637.65,62,2538.4,63,1568.16,64,6868.43,65,2694.6,66,397.73,67,213.743,68,1599.61,69,2063.02,70,7421.86,71,329.499,72,6396.88,73,494.854,74,336.758,75,2784.37,76,1936.68,77,258.915,78,359.768,79,516.683,80,840.626,81,6186.66,82,5927.53,83,3266.86,84,3540.33,85,395.505,86,6095.86,87,9477.43,88,6027.33,89,4312.57,90,230.717,91,225.974,92,4649.1,93,1524.37,94,2170.81,95,4767.68,96,1306.98,97,722.69,98,1976.72,99,583.108,100,461.052)
.param rcsLH=table(run,1,374.305,2,1457.87,3,8062.48,4,1551.85,5,1884.1,6,442.355,7,225.159,8,2320.73,9,537.634,10,663.151,11,7882.58,12,5049.28,13,326.018,14,1399.82,15,1899.23,16,1775.17,17,3841.75,18,8156.08,19,255.351,20,4030.08,21,375.336,22,3019.82,23,4850.11,24,594.983,25,1539.63,26,382.78,27,1553.64,28,228.373,29,227.582,30,905.805,31,2010.24,32,7513.46,33,1961.64,34,5986.66,35,1262.99,36,247.358,37,348.386,38,8514.57,39,4217.75,40,7801.49,41,292.599,42,246.358,43,329.815,44,6766.91,45,719.45,46,3326.58,47,767.832,48,2670.63,49,2153.83,50,1086.92,51,967.261,52,2876.73,53,432.649,54,9618.05,55,3843.76,56,1170.68,57,643.375,58,272.726,59,4489.03,60,1646.48,61,812.083,62,364.487,63,679.248,64,5094.32,65,495.664,66,6879.92,67,7976.86,68,327.038,69,1045.08,70,259.083,71,383.162,72,2386.47,73,1373.79,74,1306.76,75,681.781,76,7712.58,77,321.29,78,2320.88,79,1896.23,80,5902.88,81,925.201,82,1877.67,83,265.288,84,625.333,85,9329.97,86,220.55,87,1131.79,88,4364.82,89,320.961,90,7225.38,91,932.699,92,1051.22,93,1981.94,94,615.373,95,3946.43,96,2206.9,97,279.84,98,324.682,99,4663.72,100,1081.48)
.param rciRH=table(run,1,2196.43,2,6045.18,3,6866.85,4,6080.04,5,756.477,6,243.879,7,216.459,8,4527.8,9,1192.96,10,5199.03,11,5411.33,12,7329.16,13,227.581,14,7169.89,15,4639.12,16,7667.67,17,1434.58,18,6479.45,19,2892.54,20,3764.4,21,7422.6,22,1038.44,23,316.819,24,1254.1,25,847.145,26,2254.11,27,3695,28,730.426,29,7261.67,30,1087.3,31,365.591,32,1097.58,33,8295.52,34,6674.34,35,9073.02,36,4704.69,37,210.649,38,212.175,39,397.657,40,724.019,41,6096.68,42,1118.68,43,6393.88,44,6596.04,45,328.139,46,7829.49,47,2253.9,48,1905.35,49,1207.15,50,617.512,51,3688.38,52,2862.54,53,303.016,54,4535.15,55,9741.98,56,417.562,57,2612.41,58,687.401,59,1489.08,60,768.057,61,246.471,62,5341.29,63,511.752,64,498.197,65,1837.48,66,6437.79,67,526.105,68,4956.24,69,1767.73,70,4060.57,71,3975.44,72,6699.83,73,7974.98,74,558.493,75,5812.14,76,234.409,77,5577.8,78,1333.5,79,3952.95,80,6791.55,81,256.25,82,2886.31,83,277.74,84,1050.09,85,8249.65,86,407.384,87,4162.82,88,5591.06,89,5207.77,90,1303.43,91,608.572,92,9620.54,93,6184.1,94,1487.64,95,8343.63,96,2470.07,97,232.288,98,1522.6,99,2613.92,100,376.315)
.param rcsRH=table(run,1,237.512,2,821.877,3,1857.66,4,768.836,5,578.552,6,459.997,7,537.621,8,682.391,9,2616.18,10,2260.8,11,4181.45,12,324.079,13,1432.79,14,234.362,15,602.57,16,233.517,17,750.477,18,874.535,19,523.908,20,767.716,21,6592.41,22,5593.33,23,1505.8,24,5780.35,25,3911.28,26,4886.76,27,1108.27,28,3837.6,29,2188.47,30,345.602,31,3173.16,32,445.782,33,4890.04,34,690.548,35,1647.54,36,1665.75,37,560.963,38,376.045,39,2441.96,40,1857.45,41,1949.49,42,900.481,43,1307.02,44,7796.92,45,7189.11,46,3565.24,47,6823.31,48,2236.87,49,1808.04,50,4978.42,51,419.228,52,9394.96,53,300.035,54,262.079,55,2894.82,56,8752.08,57,5741.3,58,708.086,59,1201.65,60,2594.44,61,6785.86,62,431.324,63,861.78,64,226.542,65,667.793,66,817.876,67,627.291,68,1087.99,69,6692.91,70,1226.59,71,660.926,72,1137.97,73,3462.01,74,3992.92,75,455.072,76,6997.24,77,3653.28,78,773.105,79,358.037,80,374.792,81,6777.09,82,585.981,83,4111.47,84,2409.3,85,7519.95,86,3914.35,87,7707.76,88,924.087,89,1718.35,90,573.268,91,2390.31,92,2364.31,93,5665.46,94,1206.16,95,259.75,96,215.681,97,6291.99,98,263.795,99,1118.12,100,5102.14)
.param rciLF=table(run,1,229.959,2,2076.48,3,353.315,4,2013.34,5,8289.27,6,7184.17,7,528.862,8,5846.78,9,297.026,10,415.892,11,937.898,12,286.426,13,323.765,14,686.755,15,4605.31,16,1175.86,17,5078.91,18,568.181,19,2477.85,20,546.613,21,2732.05,22,3842.79,23,229.543,24,1154.23,25,266.334,26,339.266,27,347.39,28,544.116,29,259.985,30,253.94,31,273.525,32,3196.45,33,2452.48,34,598.954,35,249.91,36,881.16,37,338.406,38,460.818,39,3329.02,40,204.669,41,6458.96,42,1952.33,43,325.977,44,544.734,45,413.729,46,778.392,47,815.146,48,1149.33,49,214.204,50,3708.33,51,284.451,52,468.931,53,783.812,54,1385.75,55,227.601,56,1240.51,57,4543.84,58,3396.72,59,3258.2,60,1598.58,61,7774.7,62,3144.7,63,1425.44,64,1171.23,65,7289.6,66,3011.53,67,5191.26,68,3256.26,69,569.295,70,3787.25,71,1974.92,72,4552.95,73,1816.36,74,322.836,75,1062.52,76,9640.75,77,5246.03,78,549.854,79,8572.84,80,4101.31,81,9477.62,82,8020.95,83,2189.83,84,239.273,85,5075.54,86,479.103,87,9883.41,88,612.638,89,2839.29,90,225.069,91,4788.72,92,3858.7,93,8848.92,94,1813.2,95,898.826,96,524.139,97,682.429,98,309.115,99,5996.5,100,9048.11)
.param rcsLF=table(run,1,1499.03,2,252.172,3,424.639,4,2901.28,5,1138.11,6,5351.21,7,416.478,8,4521.94,9,886.405,10,1095.88,11,2457.3,12,9536.61,13,398.626,14,2091.07,15,3127.07,16,2361.59,17,887.716,18,6362.04,19,872.771,20,1107.99,21,242.683,22,746.53,23,1720.27,24,617.084,25,563.809,26,1686.07,27,797.638,28,973.522,29,1849.48,30,3819.81,31,8883.07,32,207.528,33,1522.25,34,7881.05,35,1070.32,36,787.295,37,418.312,38,280.418,39,1507.57,40,857.679,41,4348.3,42,1988.57,43,1406.06,44,200.515,45,207.15,46,268.553,47,1751.76,48,482.578,49,1407.52,50,337.821,51,1222.6,52,1458.58,53,983.474,54,500.124,55,640.669,56,3309.6,57,5839.74,58,204.515,59,3792.19,60,2931.09,61,414.738,62,376.649,63,2797.08,64,256.077,65,762.558,66,1361.42,67,6611.11,68,5086.95,69,1523.7,70,637.128,71,1398.1,72,608.628,73,1536.62,74,211.11,75,313.631,76,775.097,77,1919.46,78,3044.38,79,774.059,80,587.646,81,1478.68,82,2495.21,83,558.863,84,479.531,85,1600.2,86,549.496,87,636.079,88,512.026,89,373.96,90,4259.52,91,2212.83,92,216.781,93,6358.8,94,7352.26,95,8210.93,96,9912.68,97,319.228,98,322.26,99,3002.61,100,292.804)
.param rciRF=table(run,1,1239.08,2,911.181,3,7542.48,4,803.281,5,9261.71,6,310.459,7,1838.4,8,331.46,9,337.457,10,6350.21,11,411.526,12,315.788,13,5793.65,14,259.322,15,2480.99,16,1724.78,17,5447.53,18,1380.51,19,2418.53,20,1355.96,21,2678.99,22,270.83,23,5488.01,24,660.77,25,4804.92,26,3528.11,27,9323.45,28,3834.5,29,1203.65,30,1820.11,31,441.405,32,521.563,33,212.197,34,1436.5,35,2647.31,36,262.397,37,1959.23,38,1267.3,39,6089.31,40,8575.06,41,5995.73,42,8266.36,43,525.253,44,911.087,45,6504.94,46,3183.39,47,1134.03,48,3421.95,49,472.878,50,627.8,51,500.581,52,287.221,53,7419.69,54,298.54,55,4627.53,56,1620.64,57,1355.36,58,491.831,59,5540.6,60,524.271,61,1026.11,62,6295.85,63,8970.28,64,8569.37,65,430.989,66,599.89,67,3566.27,68,1641.13,69,2941.76,70,1244.58,71,353.765,72,1569.94,73,3013.88,74,9882.54,75,2500.61,76,3421.02,77,1903.94,78,693.669,79,9805.32,80,410.58,81,482.807,82,6629.47,83,207.403,84,300.436,85,647.868,86,8805.12,87,2583.9,88,6028.2,89,1267.39,90,749.773,91,2685.68,92,310.952,93,1164.14,94,4759.23,95,1230.52,96,729.505,97,2062.22,98,650.361,99,9268.32,100,247.837)
.param rcsRF=table(run,1,7232.2,2,707.716,3,1735.47,4,1523.92,5,1502.75,6,2122.43,7,232.952,8,4016.99,9,2669.97,10,868.519,11,3902.91,12,399.412,13,1329.67,14,504.571,15,8241.53,16,267.318,17,4316.48,18,2922.43,19,549.027,20,348.187,21,2094.13,22,335.485,23,278.241,24,270.321,25,1255.43,26,967.709,27,3771.24,28,981.679,29,1816.45,30,2770.46,31,539.263,32,8576.59,33,6521.24,34,291.747,35,249.674,36,549.551,37,1043.51,38,2030.32,39,1250.92,40,318.371,41,250.25,42,750.657,43,986.121,44,8637.65,45,2075.92,46,8980.4,47,2545.72,48,1229.06,49,904.719,50,4935.65,51,4582.92,52,929.759,53,1629.54,54,429.168,55,7438,56,274.236,57,5395.86,58,6669.67,59,4778.74,60,3179.21,61,862.65,62,439.61,63,5618.72,64,206.51,65,236.832,66,785.23,67,735.318,68,242.89,69,280.855,70,5034.83,71,3823.41,72,9242.65,73,2319.41,74,680.393,75,281.113,76,5039.83,77,1593.92,78,1903.62,79,3798.84,80,432.595,81,1678.49,82,618.578,83,1611.98,84,3611.32,85,2560.13,86,3951.42,87,919.589,88,7296.27,89,3091.48,90,1490.87,91,2208.16,92,3234.63,93,348.4,94,1014.74,95,8152.93,96,8115.6,97,5451.07,98,671.686,99,2690.31,100,202.946)
Ibp sa 0 {ibp}
Ibn sb 0 {ibn}

.end
